* ============================================================
* 5-WAY DRIVE v0.3bis — Test D2b-DC: trasferimento statico shunt JFET
* Sostituisce il CS di drive-tape.cir: il common-source distorce
* SEMPRE (0,14-0,2 % sotto il ginocchio → viola "CCW = pulito").
* Topologia shunt: sotto il ginocchio il JFET e' interdetto (canale
* spento, THD ~0, carico nullo); sopra, il canale conduce e shunta
* il nodo morbidamente (coda quadratica) → compressione calda.
* ASIMMETRIA intrinseca (volunta, famiglia nastro): lato positivo
* clippa a Vgate−Vto ≈ +1,5 V; lato negativo il canale resta acceso
* finche' il gate non va in diretta (≈ −(Vg+0,6)) → negativo piu'
* aperto → H2 presente + H3 → calore asimmetrico.
* Bias gate [PROVVISORIO — regola 3]: partitore 62k/6,8k da −18 →
* Vg ≈ −1,78 V → ginocchio ≈ 1,3-1,5 V (verifica .dc sotto).
* DOMANDE: (a) trasferimento .dc (ginocchio +/−); (b) sotto il
* ginocchio THD < 0,01 %?; (c) progressione armonica sopra (H2/H3);
* (d) impedenza di carico del partitore 2b (Rdc+Rtop ≈ 25 k) sul
* ginocchio.
* ============================================================

.model NJ310 NJF(Beta=5m Vto=-3 Lambda=6m Cgs=25p Cgd=4p Is=10f)

Vcc vcc 0 DC 18
Vee vee 0 DC -18
V1 in 0 SINE(0 {amp} 1k)

* VCA a monte = sorgente ideale per questo test (livello = post-VCA)
Rser in clip 1k
* Shunt JFET: drain=clip, source=0, gate bias −1,78
J1 clip 0 gate NJ310
Rgn vee gate 62k
Rgg gate 0 6.8k
* Carico: rete bias 2b (Rdc 100k + Rtop 33k verso +18 → ~25k verso AC)
Rload clip 0 25k

.options noopiter
.dc V1 -8 8 0.02
.meas dc knee_p WHEN V(clip)=1.2 RISE 1
.meas dc knee_n WHEN V(clip)=-2.5 FALL 1
.meas dc vclip_p3 FIND V(clip) AT 3
.meas dc vclip_n3 FIND V(clip) AT -3
.end
