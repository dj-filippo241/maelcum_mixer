* MODULO 5-WAY — PoC (c-A) cella JFET VCR: THD ai livelli reali.
* Configurazione worst: Q = 3, boost massimo (bq = +4,62: post-fix damping σ=+1),
* f0 = 700 Hz, tono a f0. Livelli: 77,5 mV = core a −20 dBu (il riferimento
* LOCALE proposto per questa topologia: vds del VCR = hp ≈ Vin_core, e la
* triode vuole vds ≤ 2(Vcm−Vt) ≈ 234-580 mV nella finestra); 245 mV = worst
* programma +10 dBu con core a −20 dBu; 388 mV = caso −6 dBu (FUORI
* finestra: dimostra perché il core scalato serve).
* THD residuo atteso: Lambda·vds (il bootstrap cancella la quadraticità).
* Make-up +20 dB post-cella = 1 sezione op-amp (già a BOM: Xout può fare
* gain invece di unity — qui THD è invariante, si misura diretto su vout).
.include ../lib/opamp-audio.inc
.param A=0.0775
.param Qval=3
.param Vcm=-1.711
.param Cint={1/(2*pi*700*9.98k)}
Vcc vcc 0 DC 18
Vee vee 0 DC -18
V1 vin 0 SINE(0 {A} 700)
Vc2 vc2 0 DC {2*Vcm}
Rvin vin ns 10k
Rlp lp_b ns 10k
* nodo -bp_b: nel design reale è l'invertitore già previsto per il pot ±bp_b
Bqd bqn 0 V={-V(bp_b)}
Rq bqn ns {Qval*10k}
Rf ns hp 10k
Xsum 0 ns hp vcc vee OP1654
Rg1a hp g1a 100k
Rg2a vc2 g1a 100k
J1 hp g1a nint1 NJFX
Cint1 nint1 bp {Cint}
Xint1 0 nint1 bp vcc vee OP1654
Rb1 bp 0 1G
Xb1 bp bp_b bp_b vcc vee OP1654
Rg1b bp_b g1b 100k
Rg2b vc2 g1b 100k
J2 bp_b g1b nint2 NJFX
Cint2 nint2 lp {Cint}
Xint2 0 nint2 lp vcc vee OP1654
Rb2 lp 0 1G
Xb2 lp lp_b lp_b vcc vee OP1654
.model NJFX NJF(Vto=-2 Beta=173u Lambda=5m)
Bw bwv 0 V={4.62/4.62*V(bp_b)}
Rbw bwv ns2 {10k*Qval/4.62}
Rain vin ns2 10k
Rf2 ns2 vout 10k
Xout 0 ns2 vout vcc vee OP1654
.step param A LIST 0.0775 0.245 0.388
.tran 0 30m 22m 0.5u
.four 700 V(vout)
.meas tran hp_pk MAX ABS(V(hp))
.meas tran bpb_pk MAX ABS(V(bp_b))
.meas tran out_pk MAX ABS(V(vout))
.end
