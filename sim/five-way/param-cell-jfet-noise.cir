* MODULO 5-WAY — PoC (c-A) cella JFET VCR: RUMORE (worst case boost, come
* param-cell-real-noise per confrontabilità: bq = +4,62 post-fix damping).
* Il VCR JFET genera termica di canale (4kT·rds: 16-20 nV/√Hz nella
* finestra) — LTspice la include nel modello JFET; op-amp = OP1654 reali.
* Confronto: cella OTA reale −119,7 dBu (Q1) / −122,7 (Q3).
* Lettura: vn2 integrato 20 Hz-20 kHz + densità.
.include ../lib/opamp-audio.inc
.param Qval=3
.param Vcm=-1.711
.param Cint={1/(2*pi*700*9.98k)}
Vcc vcc 0 DC 18
Vee vee 0 DC -18
V1 vin 0 DC 0 AC 1
Vc2 vc2 0 DC {2*Vcm}
Rvin vin ns 10k
Rlp lp_b ns 10k
* nodo -bp_b: nel design reale è l'invertitore già previsto per il pot ±bp_b
Bqd bqn 0 V={-V(bp_b)}
Rq bqn ns {Qval*10k}
Rf ns hp 10k
Xsum 0 ns hp vcc vee OP1654
Rg1a hp g1a 100k
Rg2a vc2 g1a 100k
J1 hp g1a nint1 NJFX
Cint1 nint1 bp {Cint}
Xint1 0 nint1 bp vcc vee OP1654
Rb1 bp 0 1G
Xb1 bp bp_b bp_b vcc vee OP1654
Rg1b bp_b g1b 100k
Rg2b vc2 g1b 100k
J2 bp_b g1b nint2 NJFX
Cint2 nint2 lp {Cint}
Xint2 0 nint2 lp vcc vee OP1654
Rb2 lp 0 1G
Xb2 lp lp_b lp_b vcc vee OP1654
.model NJFX NJF(Vto=-2 Beta=173u Lambda=5m)
Bw bwv 0 V={4.62/4.62*V(bp_b)}
Rbw bwv ns2 {10k*Qval/4.62}
Rain vin ns2 10k
Rf2 ns2 vout 10k
Xout 0 ns2 vout vcc vee OP1654
.step param Qval LIST 1 3
.noise V(vout) V1 dec 200 20 20k
.meas noise vn2 INTEG V(onoise)*V(onoise)
.meas noise nd1k FIND V(onoise) AT 1k
.meas noise nd100 FIND V(onoise) AT 100
.end
