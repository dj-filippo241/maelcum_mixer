* MODULE-NOISE B9 (2026-11-04, todo 245): module-noise-bande.cir col NASTRO A BANDE B9 (nastro-b9.cir) al posto di B8; GROWL A BANDE invariato. Casi utili: 0 chiuse, 3 NASTRO 100 %, 4 NASTRO 50 % (manopola; rotazione 0,75). Metodo a 16 punti (noise_total.py).
* MODULO 5-WAY v0.31 — RERUN CONSOLIDATO RUMORE (coda voce 71A,
* 2026-10-01). Base: module-noise-v03.cir (decisione 88) con TRE
* correzioni gia' decise/documentate:
* (1) Rvn 240k → 133k: il drive usa il 218x con I/V 10k = floor
*     −104 dBV (datasheet); 133k = 47 nV/√Hz esatto. Il 240k di v03
*     (63 nV = −101 dBV) sovrastimava il drive ~2,6 dB — finding in
*     sim/cdj/RISULTATI-channel-noise-71A.md "Finding di metodo".
* (2) Gate π SPDT reali al posto dei 5 Rsw 33 Ω: switch ON-pass =
*     Ron 4,7 Ω serie (ADG1434) + Coff 30p nodo→GND (shunt aperto).
*     Design: five-way §8.10 + RISULTATI-gate-switch.md.
* (3) 2 invertitori unity su SUB e MID (bande DISPARI di AP2, §8.10:
*     la polarita' telescopica ora la fanno loro, non il VCA): R 2k,
*     macro OPAMP (Rn 1223 = classe OPA1654). Stima: +~0,3 dB banca.
* Catena invariata: pad −6 → banca → gate switch → summer → 5 celle
* v0.2.1 detent → drive v0.3 (218x I/V 10k, NJ310, pair PNP, servo
* OPA2134-class) → make-up +6 → vout.
* TARGET (dec. 88/89): ≤ −80 dBu A-wtd, out modulo, ingressi terminati,
* gain nominali, drive θ0. RISULTATI: RISULTATI-module-noise-v031.md.
*
* METODOLOGIA (quirk LTspice 26.0.2 — RISULTATI-module-noise-v021.md §1):
* totali MAI da .meas INTEG (restituisce en²·√Δf): densità a 10 punti +
* trapezoidale python + A-wtd IEC 61672 post. Iniezioni rumore con E
* LINEARE 4 nodi. VCAM 218x INLINE con nomi unici (subckt + banca
* SK/AP2 = bug parse "Instance already defined").
* Rumore 218x da datasheet THAT: −98 dBV a 0 dB gain (Rout 20k);
* −104 dBV typ con I/V 10k → Rvn 133k (47 nV/√Hz).
* Ripartizione delta vs v03: varianti module-noise-v031a.cir (solo
* correzione 1) e -v031b.cir (correzioni 1+3, switch come v03).
* ============================================================
.include ../lib/opamp-audio.inc
.model NJFX NJF(Vto=-2 Beta=173u Lambda=5m)
.model NJ310 NJF(Beta=5m Vto=-3 Lambda=6m Cgs=25p Cgd=4p Is=10f)
.model PNP3906 PNP(Is=1.72f Bf=190 Vaf=49.7 Ikr=0.237 Ne=2 Ise=43.4f Ikf=0.222 Br=4.9 Rb=1 Rc=3.7 Cje=19.2p Mje=0.37 Vje=0.75 Cjc=9.7p Mjc=0.34 Vjc=0.75 Fc=0.5 Tf=2.1n Tr=200n)
.param kcase=0
.param th=0.5
*
* --- macro uniforme ~6 nV/√Hz per la banca (metodologia v0.2 §8.4) ---
.subckt OPAMP inp inn out vp vm
Rn inp inx 1223
E1 xx 0 inx inn 1e6
R1 xx p1 5005
C1 p1 0 1.59u
E2 out 0 value={limit(V(p1),V(vm)+1.5,V(vp)-1.5)}
.ends OPAMP
.subckt SKLP in out PARAMS: fc=90 Cc=100n
R1 in n1 {1/(2*pi*fc*sqrt(2)*Cc)}
R2 n1 n2 {1/(2*pi*fc*sqrt(2)*Cc)}
C1 n1 out {2*Cc}
C2 n2 0 {Cc}
Xop n2 out out vcc vee OPAMP
.ends SKLP
.subckt SKHP in out PARAMS: fc=90 Cc=10n
C1 in n1 {Cc}
C2 n1 n2 {Cc}
R1 n1 out {1/(2*pi*fc*sqrt(2)*Cc)}
R2 n2 0 {2/(2*pi*fc*sqrt(2)*Cc)}
Xop n2 out out vcc vee OPAMP
.ends SKHP
.subckt MFBPB in out PARAMS: f0=1200 C=10n
R1 in n1 {1/(sqrt(2)*2*pi*f0*C)}
R2 n1 0 {2/(sqrt(2)*2*pi*f0*C)}
C1 n1 nm {2*C}
Rf nm out {1.5/(sqrt(2)*2*pi*f0*C)}
C2 n1 out {C}
Xop 0 nm out vcc vee OPAMP
.ends MFBPB
.subckt APSUM va vb out PARAMS: R=10k
Ra va n {R}
Rb vb n {R/2}
Rf n out {R}
Xop 0 n out vcc vee OPAMP
.ends APSUM
.subckt AP2 in out PARAMS: f0=1200 C=10n
Xbp in bp MFBPB f0={f0} C={C}
Xsm in bp out APSUM
.ends AP2
* --- invertitore unity per polarita' gate (§8.10: bande DISPARI di AP2) ---
.subckt INVU in out
Rin in n 2k
Rf n out 2k
Xop 0 n out vcc vee OPAMP
.ends INVU
*
* --- CELLA v0.2.1 (five-way §4.2): 7 OP1654 + 2 JFET VCR + pot detent ---
.subckt PCELL21 vin out PARAMS: Cv=56n Vcmv=-1.39 Qv=1
Vc2 vc2 0 DC {2*Vcmv}
Rvin vin ns 40.2k
Rlp lp_b ns 10k
Bqd bqn 0 V={-V(bp_b)}
Rq bqn ns {Qv*10k}
Rf ns hp 10k
Xsum 0 ns hp vcc vee OP1654
Rg1a hp g1a 100k
Rg2a vc2 g1a 100k
J1 hp g1a nint1 NJFX
Cint1 nint1 bp {Cv}
Xint1 0 nint1 bp vcc vee OP1654
Rb1 bp 0 1G
Xb1 bp bp_b bp_b vcc vee OP1654
Rg1b bp_b g1b 100k
Rg2b vc2 g1b 100k
J2 bp_b g1b nint2 NJFX
Cint2 nint2 lp {Cv}
Xint2 0 nint2 lp vcc vee OP1654
Rb2 lp 0 1G
Xb2 lp lp_b lp_b vcc vee OP1654
Rib1 bp_b nbi 10k
Ribf nbi nbp 10k
Xinv 0 nbi nbp vcc vee OP1654
RpT bp_b wp 5k
RpB nbp wp 5k
Rbw wp ns2 {2.5k*Qv/4.62}
Rain vin ns2 10k
Rf2 ns2 out 10k
Xout 0 ns2 out vcc vee OP1654
.ends PCELL21
*
* --- VCA: vedi inline nella sezione drive (subckt rimosso: bug flattening
*     LTspice 26.0.2 con banca SK/AP2 → 'Instance already defined') ---
.subckt OPAMP0 inp inn out
E1 out 0 value={limit(1e5*(V(inp)-V(inn)),-16,16)}
.ends OPAMP0
*
Vcc vcc 0 DC 18
Vee vee 0 DC -18
V1 vin 0 DC 0 AC 1
*
* --- PAD −6 dB (20k/20k) + buffer ---
Rpad1 vin npad 20k
Rpad2 npad 0 20k
Xpad npad vpad vpad vcc vee OPAMP
*
* --- BANCA allineata (kcase=0: tutti i gate in pass) ---
XH1 vpad r1 SKHP fc=90 Cc=100n
XH1b r1 r1b SKHP fc=90 Cc=100n
XH2 r1b r2 SKHP fc=350 Cc=100n
XH2b r2 r2b SKHP fc=350 Cc=100n
XH3 r2b r3 SKHP fc=1200 Cc=10n
XH3b r3 r3b SKHP fc=1200 Cc=10n
XH4 r3b r4 SKHP fc=3500 Cc=10n
XH4b r4 r4b SKHP fc=3500 Cc=10n
XA1 vpad s1a SKLP fc=90 Cc=100n
XA2 s1a s1b SKLP fc=90 Cc=100n
XP1 s1b s1c AP2 f0=350 C=22n
XP2 s1c s1d AP2 f0=1200 C=10n
XP3 s1d sub_o AP2 f0=3500 C=2.2n
XB1 r1b s2b SKLP fc=350 Cc=100n
XB2 s2b s2c SKLP fc=350 Cc=100n
XP4 s2c s2d AP2 f0=1200 C=10n
XP5 s2d kick_o AP2 f0=3500 C=2.2n
XC1 r2b s3c SKLP fc=1200 Cc=10n
XC2 s3c s3d SKLP fc=1200 Cc=10n
XP6 s3d mid_o AP2 f0=3500 C=2.2n
XD1 r3b s4c SKLP fc=3500 Cc=10n
XD2 s4c high_o SKLP fc=3500 Cc=10n
*
* --- INVERTITORI POLARITA' (correzione 3: SUB e MID = bande DISPARI AP2) ---
XI1 sub_o sub_i INVU
XI3 mid_o mid_i INVU
*
* --- KILL A SWITCH π SPDT (correzione 2, dec. 88 + §8.10): ON-pass =
*     Ron 4,7 Ω serie + Coff 30p nodo→GND (shunt aperto); per il rumore
*     il solo stato pass conta (kcase=0, tutti i gate chiusi) ---
Rsw1 sub_i sub_g 4.7
Csw1 sub_g 0 30p
Rsw2 kick_o kick_g 4.7
Csw2 kick_g 0 30p
Rsw3 mid_i mid_g 4.7
Csw3 mid_g 0 30p
Rsw4 high_o high_g 4.7
Csw4 high_g 0 30p
Rsw5 r4b sup_g 4.7
Csw5 sup_g 0 30p
*
* --- SUMMER ---
Rs1 sub_g ns 10k
Rs2 kick_g ns 10k
Rs3 mid_g ns 10k
Rs4 high_g ns 10k
Rs5 sup_g ns 10k
Rsf ns vsum 10k
Xsum 0 ns vsum vcc vee OPAMP
*
* --- 5 CELLE v0.2.1 a detent (centri come v0.2; Vcm da formula §4.2) ---
XE1 vsum e1 PCELL21 Cv=680n Vcmv=-1.257 Qv=1
XE2 e1 e2 PCELL21 Cv=180n Vcmv=-1.410 Qv=1
XE3 e2 e3 PCELL21 Cv=56n Vcmv=-1.390 Qv=3
XE4 e3 e4 PCELL21 Cv=18n Vcmv=-1.346 Qv=1
XE5 e4 e5 PCELL21 Cv=4.7n Vcmv=-1.317 Qv=0.5
*
* --- DRIVE A BANDE (dec. 165 e 166, todo 234, 2026-11-04): GROWL A BANDE
*     (growl-bande.cir) e NASTRO A BANDE (nastro-bande.cir) con op-amp
*     OP1654 rumorosi, pot doppi come resistenze, miscele con buffer e
*     sommatori 2,2k come module-noise-p2.cir.
*     Casi: 0 chiuse | 1 GROWL BANDE 100 % | 2 GROWL BANDE 50 % |
*     3 NASTRO BANDE 100 % | 4 NASTRO BANDE 50 % | 5 entrambe 100 % ---
.model D4148 D(Is=2.52n Rs=0.568 N=1.752 Cjo=4p M=0.4 tt=20n)
.param case=0
.param tg={if(case==1|case==5,1,if(case==2,0.5,0))}
.param tn={if(case==3|case==5,1,if(case==4,0.5,0))}
.param kt=0.206
.param kl=0.1977
* GROWL A BANDE: parametri come growl-bande.cir
.param fl=250
.param fm=2500
.param gLmax=20
.param rfl=47k
.param rsl=470
.param kbl=0.9
.param gMmax=6
.param rfm=10k
.param rsm=4.7k
.param kbm={1/(rfm/10k*pow(10,gMmax/20))}
.param gbl={pow(10,gLmax*tg/20)}
.param gbm={pow(10,gMmax*tg/20)}
Rga1 e5 ga1 10k
Rga2 ga1 ga2 10k
Cga1 ga1 glp1 {1.4142/(6.2832*fl*10k)}
Cga2 ga2 0 {0.7071/(6.2832*fl*10k)}
Xga ga2 glp1 glp1 vcc vee OP1654
Rgb1 glp1 gb1 10k
Rgb2 gb1 gb2 10k
Cgb1 gb1 glow {1.4142/(6.2832*fl*10k)}
Cgb2 gb2 0 {0.7071/(6.2832*fl*10k)}
Xgb gb2 glow glow vcc vee OP1654
Rgr1 e5 grp 10k
Rgr2 grp 0 10k
Rgr3 glow grn 10k
Rgr4 grn grest 10k
Xgr grp grn grest vcc vee OP1654
Rgm1 grest gmc 10k
Cgm1 gmc 0 {1/(6.2832*fm*10k)}
Xgm gmc gmid gmid vcc vee OP1654
Rgli glow glgn {10k/gbl}
Rglf glgn glout {rfl}
Dgla glgn gla1 D4148
Rgla gla1 glout {rsl}
Dglb1 glout glb1 D4148
Dglb2 glb1 glb2 D4148
Dglb3 glb2 glb3 D4148
Rglb glb3 glgn {rsl}
Xgl 0 glgn glout vcc vee OP1654
Rgmi gmid gmgn {10k/gbm}
Rgmf gmgn gmout {rfm}
Dgma1 gmgn gma1 D4148
Dgma2 gma1 gma2 D4148
Dgma3 gma2 gma3 D4148
Rgma gma3 gmout {rsm}
Dgmb1 gmout gmb1 D4148
Dgmb2 gmb1 gmb2 D4148
Dgmb3 gmb2 gmb3 D4148
Rgmb gmb3 gmgn {rsm}
Xgmc 0 gmgn gmout vcc vee OP1654
Cglc glout glac {kbl/(6.2832*10k)}
Rgls glac gdn {10k/kbl}
Cgmc gmout gmac {kbm/(6.2832*10k)}
Rgms gmac gdn {10k/kbm}
Rgll glow gdn 10k
Rgmm gmid gdn 10k
Rgdo gdn ddg 10k
Xgd 0 gdn ddg vcc vee OP1654
* pot GROWL (tratto miscela) + buffer, sommatore 2,2k
Rdpg1 ddg dwg {10k*(1-tg)+1m}
Rdpg2 dwg 0 {10k*tg+1m}
Xdbg dwg dbg dbg vcc vee OP1654
Rds1x e5 ds1n 2.2k
Rds1w dbg ds1n 2.2k
Rds1f ds1n dy1 2.2k
Xds1 0 ds1n dy1 vcc vee OP1612
* NASTRO A BANDE B9 (todo 245): parametri e celle come nastro-b9.cir
* manopola a curva inversa: rotn = 1-(1-tn)^2 (spinta e pot di miscela)
.param rotn={1-(1-tn)*(1-tn)}
.param fz=30
.param fp=140
.param fa=9000
.param fb=10800
.param rl=12
.param rh=5
.param nl=3
.param fmt=1000
.param rt=3
.param kvdb=-3.5
.param gl={(fp/fz)*pow(10,-rl/nl/20)}
.param gh={(fb/fa)*pow(10,-rh/20)}
.param kv={pow(10,kvdb/20)}
.param rel={10k*(fp/fz-1)}
.param reh={10k*(fb/fa-1)}
.param ret={10k*(rt-1)}
.param rdh={10k*(1/gh-1)}
.param rdl={10k*(gl-1)}
.param rkb={10k*kv/(2-kv)}
Rne1 dy1 ne1 {rel}
Cne1 dy1 ne1 {1/(6.2832*fz*rel)}
Rne1g ne1 0 10k
Xne1 ne1 nu1 nu1 vcc vee OP1654
Rne2 nu1 ne2 {rel}
Cne2 nu1 ne2 {1/(6.2832*fz*rel)}
Rne2g ne2 0 10k
Xne2 ne2 nu2 nu2 vcc vee OP1654
Rne3 nu2 ne3 {rel}
Cne3 nu2 ne3 {1/(6.2832*fz*rel)}
Rne3g ne3 0 10k
Xne3 ne3 nu3 nu3 vcc vee OP1654
Rne4 nu3 ne4 {reh}
Rne4g ne4 ne4c 10k
Cne4 ne4c 0 {1/(6.2832*fb*10k)}
Xne4 ne4 nu4 nu4 vcc vee OP1654
Rne5 nu4 nu {ret}
Rne5g nu ne5c 10k
Cne5 ne5c 0 {1/(6.2832*fmt*rt*10k)}
* spinta non invertente (Rg 1k, Rf = 1k (g - 1)), JFET, wn = -kl vtac
Rlsg lsn 0 1k
Rlsf lsp lsn {1k*(pow(10,12*rotn/20)-1)+1m}
Xls nu lsn lsp vcc vee OP1654
Rltg lsp lgate 10k
J2d ldrain lgate ljs1 NJ310
Rld vcc ldrain 1.5k
Rlsu ljs1 ljs2 150
Rlsb ljs2 0 900
Clb ljs2 0 2200u
Clta ldrain ltac 10u
Rlts ltac ltn {10k/kt}
Rltf ltn nwn {10k*kl/kt}
Xlt 0 ltn nwn vcc vee OP1654
Rnd1 nwn nd1 {rdh}
Rnd1g nd1 nd1c 10k
Cnd1 nd1c 0 {1/(6.2832*fa*10k)}
Rnd2f nw2 nd2n {ret}
Rnd2g nd2n nd2c 10k
Cnd2 nd2c 0 {1/(6.2832*fmt*rt*10k)}
Xnd2 nd1 nd2n nw2 vcc vee OP1654
Rnd3g nd3n 0 10k
Rnd3f nw3 nd3n {rdl}
Cnd3f nw3 nd3n {gl/(6.2832*fp*rdl)}
Xnd3 nw2 nd3n nw3 vcc vee OP1654
Rnd4g nd4n 0 10k
Rnd4f nw4 nd4n {rdl}
Cnd4f nw4 nd4n {gl/(6.2832*fp*rdl)}
Xnd4 nw3 nd4n nw4 vcc vee OP1654
Rnd5g nd5n 0 10k
Rnd5f nw nd5n {rdl}
Cnd5f nw nd5n {gl/(6.2832*fp*rdl)}
Xnd5 nw4 nd5n nw vcc vee OP1654
* d = kv w - y1 (differenziale, 4 R; partitore 10k / rkb sul +)
Rnx1 nw nxp 10k
Rnx2 nxp 0 {rkb}
Rnx3 dy1 nxn 10k
Rnx4 nxn dsel 10k
Xnx nxp nxn dsel vcc vee OP1654
* pot NASTRO (10k + 1,8k sopra, lineare sulla rotazione: mt = 0,85 rotn)
Rdpt1 dsel dwt {1.8k+10k*(1-rotn)+1m}
Rdpt2 dwt 0 {10k*rotn+1m}
Xdbt dwt dbt dbt vcc vee OP1654
Rds2x dy1 ds2n 2.2k
Rds2w dbt ds2n 2.2k
Rds2f ds2n dy2 2.2k
Xds2 0 ds2n dy2 vcc vee OP1612
Rser2 dy2 edrv 33
*
* --- MAKE-UP +6 dB (gain −2) ---
Rmu1 edrv nmu 10k
Rmu2 nmu vout 20k
Xmu 0 nmu vout vcc vee OPAMP
*
.options method=gear reltol=1e-4
.nodeset V(ljs2)=2.1 V(ldrain)=14.5
.noise V(vout) V1 dec 50 20 20k
.step param case LIST 0 3 4
.meas noise on1 FIND V(onoise) AT 20
.meas noise on2 FIND V(onoise) AT 31.5
.meas noise on3 FIND V(onoise) AT 50
.meas noise on4 FIND V(onoise) AT 80
.meas noise on5 FIND V(onoise) AT 125
.meas noise on6 FIND V(onoise) AT 200
.meas noise on7 FIND V(onoise) AT 315
.meas noise on8 FIND V(onoise) AT 500
.meas noise on9 FIND V(onoise) AT 800
.meas noise on10 FIND V(onoise) AT 1250
.meas noise on11 FIND V(onoise) AT 2000
.meas noise on12 FIND V(onoise) AT 3150
.meas noise on13 FIND V(onoise) AT 5000
.meas noise on14 FIND V(onoise) AT 8000
.meas noise on15 FIND V(onoise) AT 12500
.meas noise on16 FIND V(onoise) AT 20000
.meas noise g1k FIND gain AT 1000
.meas noise g50 FIND gain AT 50
.meas noise g8k FIND gain AT 8000
.end
