* ============================================================
* BANCA ALLINEATA v0.3 + GATE A SWITCH REALI (redesign dec. 88)
* VERIFICA POLARITA': la somma telescopica LR4 richiede segni uniformi
* al summer; polarita' naturali della banca (AP2 invertenti):
*   SUB −(3 AP2)  KICK +(2)  MID −(1)  HIGH +(0)  SUPER +(0)
* Il gate VCA (invertente) correggeva il segno; lo switch in serie NO
* → 2 invertitori unity per lato su SUB e MID = bande con numero DISPARI
* di AP2 (doc §3.1; prima stesura li metteva su KICK/HIGH seguendo il
* netlist v0.1 bank-lr4 = bank non allineata: nulla a 3,5 kHz, trovato
* e fixato qui). R 2k 0,1% matched, stessa disciplina delle coppie AP2. Banca INTATTA (sezioni validate
* §8.2 non modificate — opzione "scambio SK→MFB" scartata: tocca il
* cuore di precisione).
* Switch classe ADG1434: Ron 4.7 ohm (sotto la classe 33 ohm di dec.
* 88), Coff 30p rappresentativa (sweep in gate-sw-iso.cir).
* Topologia gate: PI-SPDT = serie al summer + shunt a GND da off
* (residuo off ≈ Ron_shunt/Xc_Coff, vedi gate-sw-iso.cir).
* kcase: 0=nessuno 1=SUB 2=KICK 3=MID 4=HIGH 5=SUPER 6=ALL.
* ATTESO: kcase=0 piatto come §8.2 (−0.0002…−0.008 dB) meno il guadagno
* uniforme −0.04% da Ron (assorbito dal make-up); kill = silenzio con
* residuo = off-isolation del PI.
* METODO: solo .ac/.meas FIND (nessun INTEG — quirk §8.9).
* ============================================================
.step param kcase LIST 0 1 2 3 4 5 6
*
.subckt OPAMP inp inn out vp vm
* Macro classe OPA1654 come bank-aligned.cir (A0 = 120 dB, polo 20 Hz):
* la macro v0.1 (A0 = 60 dB) darebbe ~0,15 dB di errore di loop = artefatto.
E1 xx 0 value={1e6*(V(inp)-V(inn))}
R1 xx p1 50Meg
C1 p1 0 159p
E2 out 0 value={limit(V(p1),V(vm)+1.5,V(vp)-1.5)}
.ends OPAMP
.subckt SKLP in out PARAMS: fc=90 Cc=100n
R1 in n1 {1/(2*pi*fc*sqrt(2)*Cc)}
R2 n1 n2 {1/(2*pi*fc*sqrt(2)*Cc)}
C1 n1 out {2*Cc}
C2 n2 0 {Cc}
Xop n2 out out vcc vee OPAMP
.ends SKLP
.subckt SKHP in out PARAMS: fc=90 Cc=10n
C1 in n1 {Cc}
C2 n1 n2 {Cc}
R1 n1 out {1/(2*pi*fc*sqrt(2)*Cc)}
R2 n2 0 {2/(2*pi*fc*sqrt(2)*Cc)}
Xop n2 out out vcc vee OPAMP
.ends SKHP
.subckt MFBPB in out PARAMS: f0=1200 C=10n
R1 in n1 {1/(sqrt(2)*2*pi*f0*C)}
R2 n1 0 {2/(sqrt(2)*2*pi*f0*C)}
C1 n1 nm {2*C}
Rf nm out {1.5/(sqrt(2)*2*pi*f0*C)}
C2 n1 out {C}
Xop 0 nm out vcc vee OPAMP
.ends MFBPB
.subckt APSUM va vb out PARAMS: R=10k
Ra va n {R}
Rb vb n {R/2}
Rf n out {R}
Xop 0 n out vcc vee OPAMP
.ends APSUM
.subckt AP2 in out PARAMS: f0=1200 C=10n
Xbp in bp MFBPB f0={f0} C={C}
Xsm in bp out APSUM
.ends AP2
.subckt INVU in out PARAMS: R=2k
Rin in n {R}
Rf n out {R}
Xop 0 n out vcc vee OPAMP
.ends INVU
*
Vcc vcc 0 DC 18
Vee vee 0 DC -18
V1 vpad 0 DC 0 AC 1
*
* --- SPINA HP condivisa ---
XH1 vpad r1 SKHP fc=90 Cc=100n
XH1b r1 r1b SKHP fc=90 Cc=100n
XH2 r1b r2 SKHP fc=350 Cc=100n
XH2b r2 r2b SKHP fc=350 Cc=100n
XH3 r2b r3 SKHP fc=1200 Cc=10n
XH3b r3 r3b SKHP fc=1200 Cc=10n
XH4 r3b r4 SKHP fc=3500 Cc=10n
XH4b r4 r4b SKHP fc=3500 Cc=10n
* --- SUB: LP4(90) + 3 AP2 → polarita' − ---
XA1 vpad s1a SKLP fc=90 Cc=100n
XA2 s1a s1b SKLP fc=90 Cc=100n
XP1 s1b s1c AP2 f0=350 C=22n
XP2 s1c s1d AP2 f0=1200 C=10n
XP3 s1d sub_o AP2 f0=3500 C=2.2n
XI1 sub_o sub_i INVU
* --- KICK: HP spina + LP4(350) + 2 AP2 → + ---
XB1 r1b s2b SKLP fc=350 Cc=100n
XB2 s2b s2c SKLP fc=350 Cc=100n
XP4 s2c s2d AP2 f0=1200 C=10n
XP5 s2d kick_o AP2 f0=3500 C=2.2n
* --- MID: HP spina + LP4(1.2k) + 1 AP2 → − → INVERTITO ---
XC1 r2b s3c SKLP fc=1200 Cc=10n
XC2 s3c s3d SKLP fc=1200 Cc=10n
XP6 s3d mid_o AP2 f0=3500 C=2.2n
XI3 mid_o mid_i INVU
* --- HIGH: HP spina + LP4(3.5k) → + ---
XD1 r3b s4c SKLP fc=3500 Cc=10n
XD2 s4c high_o SKLP fc=3500 Cc=10n
* --- SUPER: presa fine spina → + ---
*
* --- GATE PI-SPDT (serie + shunt a GND da off) ---
.model SWKILL SW(Ron=4.7 Roff=1G Vt=2.5)
Sw1 sub_i g1n c1n 0 SWKILL
Csw1 sub_i g1n 30p
Bc1 c1n 0 V={5*if(kcase==1,0,if(kcase==6,0,1))}
Sh1 g1n 0 h1n 0 SWKILL
Csh1 g1n 0 30p
Bh1 h1n 0 V={5*if(kcase==1,1,if(kcase==6,1,0))}
Sw2 kick_o g2n c2n 0 SWKILL
Csw2 kick_o g2n 30p
Bc2 c2n 0 V={5*if(kcase==2,0,if(kcase==6,0,1))}
Sh2 g2n 0 h2n 0 SWKILL
Csh2 g2n 0 30p
Bh2 h2n 0 V={5*if(kcase==2,1,if(kcase==6,1,0))}
Sw3 mid_i g3n c3n 0 SWKILL
Csw3 mid_i g3n 30p
Bc3 c3n 0 V={5*if(kcase==3,0,if(kcase==6,0,1))}
Sh3 g3n 0 h3n 0 SWKILL
Csh3 g3n 0 30p
Bh3 h3n 0 V={5*if(kcase==3,1,if(kcase==6,1,0))}
Sw4 high_o g4n c4n 0 SWKILL
Csw4 high_o g4n 30p
Bc4 c4n 0 V={5*if(kcase==4,0,if(kcase==6,0,1))}
Sh4 g4n 0 h4n 0 SWKILL
Csh4 g4n 0 30p
Bh4 h4n 0 V={5*if(kcase==4,1,if(kcase==6,1,0))}
Sw5 r4b g5n c5n 0 SWKILL
Csw5 r4b g5n 30p
Bc5 c5n 0 V={5*if(kcase==5,0,if(kcase==6,0,1))}
Sh5 g5n 0 h5n 0 SWKILL
Csh5 g5n 0 30p
Bh5 h5n 0 V={5*if(kcase==5,1,if(kcase==6,1,0))}
*
* --- Somma invertente (5 ingressi 10k, Rf 10k) — come bank-lr4/v03 ---
Rs1 g1n ns 10k
Rs2 g2n ns 10k
Rs3 g3n ns 10k
Rs4 g4n ns 10k
Rs5 g5n ns 10k
Rsf ns vsum 10k
Xsum 0 ns vsum vcc vee OPAMP
*
.ac dec 400 5 60k
.meas ac g10 FIND mag(V(vsum)) AT 10
.meas ac g30 FIND mag(V(vsum)) AT 30
.meas ac g90 FIND mag(V(vsum)) AT 90
.meas ac g200 FIND mag(V(vsum)) AT 200
.meas ac g350 FIND mag(V(vsum)) AT 350
.meas ac g700 FIND mag(V(vsum)) AT 700
.meas ac g1k2 FIND mag(V(vsum)) AT 1200
.meas ac g2k5 FIND mag(V(vsum)) AT 2500
.meas ac g3k5 FIND mag(V(vsum)) AT 3500
.meas ac g7k FIND mag(V(vsum)) AT 7000
.meas ac g15k FIND mag(V(vsum)) AT 15000
.meas ac g25k FIND mag(V(vsum)) AT 25000
.meas ac gmax MAX mag(V(vsum))
.end
