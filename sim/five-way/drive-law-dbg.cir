* 5-WAY DRIVE — debug shaper law (nodi DC per passo th)
* Fot copia della catena CV di drive-law.cir, analisi .tran (batch:
* una sola analisi per netlist — errore "More than one analysis").
.param th=0.5
Vcc vcc 0 DC 18
Vee vee 0 DC -18
V1 in 0 DC 1m
Vpot w 0 DC {5*th}
Bdb lawv 0 V={if(V(w)<2.5, -10+2.8*V(w), if(V(w)<4, -3+(V(w)-2.5)*3.3333, 2+(V(w)-4)*4))}
Becp ecp 0 V={0.0061*max(0,V(lawv))}
Becm ecm 0 V={0.0061*max(0,-V(lawv))}
.subckt VCAM in out ecp ecm vp vm PARAMS: km=0.122
Bg nout0 0 V={V(in)*limit(10**((V(ecp)-V(ecm))/km),1e-5,100)}
Rpol nout0 nout1 1k
Cpol nout1 0 8p
Eout out 0 value={limit(V(nout1),V(vm)+1.5,V(vp)-1.5)}
.ends VCAM
X1 in out ecp ecm vcc vee VCAM km=0.122
Rl out 0 10k
.step param th LIST 0 0.25 0.5 0.65 0.8 0.9 1.0
.tran 0 2u 0 1u
.meas tran dbg_w FIND V(w) AT 1.9u
.meas tran dbg_lawv FIND V(lawv) AT 1.9u
.meas tran dbg_ecp FIND V(ecp) AT 1.9u
.meas tran dbg_ecm FIND V(ecm) AT 1.9u
.meas tran dbg_gain FIND V(out)/1m AT 1.9u
.end
