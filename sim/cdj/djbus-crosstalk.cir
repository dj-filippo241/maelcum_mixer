* CDJ §7 item 4 — SUMMING DJ BUS: crosstalk tra canali via nodo di bus
* Solo ch1 eccitato (AC 1 V); il crosstalk verso gli altri canali è la
* tensione residua sul nodo virtual earth ns (ogni driver la vede come
* disturbo di carico). Misura: |V(ns)| a 10 Hz…35 kHz (decade il loop
* gain: peggiore in alto). Stessa topologia di djbus-level.cir.
.include ../lib/opamp-audio.inc
Vcc vcc 0 DC 18
Vee vee 0 DC -18
V1 c1 0 DC 0 AC 1
* canali inattivi: driver a 0 V (Z sorgente 47 Ω verso massa)
V2 c2 0 DC 0
V3 c3 0 DC 0
V4 c4 0 DC 0
Rd1 c1 d1 47
Rd2 c2 d2 47
Rd3 c3 d3 47
Rd4 c4 d4 47
R1 d1 ns 10k
R2 d2 ns 10k
R3 d3 ns 10k
R4 d4 ns 10k
Rf ns vout 10k
Xsum 0 ns vout vcc vee OP1612
.ac dec 200 10 40k
.meas ac xt10 FIND mag(V(ns)) AT 10
.meas ac xt100 FIND mag(V(ns)) AT 100
.meas ac xt1k FIND mag(V(ns)) AT 1k
.meas ac xt10k FIND mag(V(ns)) AT 10k
.meas ac xt20k FIND mag(V(ns)) AT 20k
.meas ac xt35k FIND mag(V(ns)) AT 35k
.meas ac xtmax MAX mag(V(ns))
.end
