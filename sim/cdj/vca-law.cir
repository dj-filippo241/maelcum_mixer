* CDJ §7 item 4 — THAT 218x come VCA di GAIN: law dB(θ) e tracking L/R
* Catena §3.2: pot 5 V (θ) → shaper lineare-in-dB a tratti → porti EC → VCA.
*   metà CCW: ECm = (2,5−Vw)·0,244 → G = −100…0 dB (6,1 mV/dB, floor −100)
*   metà CW:  ECp = (Vw−2,5)·0,0244 → G = 0…+10 dB
* km = costante di law del macromodello (V/decade-step): 0,122 = typ
* (6,1 mV/dB); 0,120/0,124 = min/max datasheet (±1,6%) → effetto sul
* tracking L/R SENZA trim di law (dato per questione 53/voce 37: col 2181
* trimmabile le due law si eguagliano al trim; col 2180 serve selezione).
* Stessa law di sim/lib/that2181.inc, qui con km parametrabile.
* Shaper comportamentale: implementazione op-amp = cdj v0.4 / FX v0.2.
.param th=0.5
.param km=0.122
Vcc vcc 0 DC 18
Vee vee 0 DC -18
V1 in 0 DC 0 AC 1
Vpot w 0 DC {5*th}
Becm ecm 0 V={max(0,(2.5-V(w)))*0.244}
Becp ecp 0 V={max(0,(V(w)-2.5))*0.0244}
*
.subckt VCAM in out ecp ecm vp vm PARAMS: km=0.122
Bg nout0 0 V={V(in)*limit(10**((V(ecp)-V(ecm))/km),1e-5,100)}
Rpol nout0 nout1 1k
Cpol nout1 0 8p
Eout out 0 value={limit(V(nout1),V(vm)+1.5,V(vp)-1.5)}
.ends VCAM
X1 in out ecp ecm vcc vee VCAM km={km}
*
.step param th LIST 0 0.1 0.25 0.5 0.625 0.75 0.875 1.0
.step param km LIST 0.120 0.122 0.124
.ac dec 100 100 10k
.meas ac g100 FIND mag(V(out)) AT 100
.meas ac g1k FIND mag(V(out)) AT 1k
.meas ac g10k FIND mag(V(out)) AT 10k
.end
