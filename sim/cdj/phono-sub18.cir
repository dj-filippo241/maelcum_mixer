* PHONO — SUBSONICA A 18 Hz (dec. 138, 2026-10-27)
* Copia di phono-sub100-fix.cir con la Sallen-Key HP spostata da 13 a 18 Hz
* (Q 0,707, R_fb = R_gnd/2, C uguali 100n): Rs1 61,9k, Rs2 124k -> f0 18,2 Hz.
* Misure in piu': 10 Hz (warp), 37 e 40 Hz (fondo del VENU360), fase a 40 Hz.
.include ../lib/opamp-audio.inc
.param Cload=200p
Vcc vcc 0 DC 15
Vee vee 0 DC -15
Vcart cart 0 DC 0 AC 1
Rcart cart in 660
Rload in 0 47k
Cload in 0 {Cload}
* --- [A1] stadio 1 non-inv x21 ---
X1 in fb1 s1 vcc vee OP1612
Rg1 fb1 0 1k
Rf1 fb1 s1 20k
* --- [A2] Sallen-Key HP 2 poli 18 Hz Q 0,707 unity (dec. 138) ---
Cs1 s1 n1 100n
Cs2 n1 s2a 100n
Rs1 n1 s2 61.9k
Rs2 s2a 0 124k
X2 s2a s2 s2 vcc vee OP1612
* --- [A3] rete RIAA passiva ---
Rr1 s2 p 21.8k
Cr1 p 0 34.8n
Rr2 p p2 3.16k
Cr2 p2 0 100n
* --- [A4] DC block: polo 1,59 Hz (FIX: era 15,9 Hz) ---
* NB: C3 preleva da p (nodo d'uscita della rete, come nell'originale),
* non da p2 (nodo interno Rr2/Cr2).
C3 p q 100n
Rb2 q 0 1Meg
* --- [A5] stadio 2 non-inv x60,6 ---
X3 q qn vout vcc vee OP1654
Rg2 qn 0 1k
Rf2 qn vout 59.6k

.ac dec 200 5 100k
.meas ac g10 FIND mag(V(vout)) AT 10
.meas ac g37 FIND mag(V(vout)) AT 37
.meas ac g40 FIND mag(V(vout)) AT 40
.meas ac s40 FIND V(s2) AT 40
.meas ac s10 FIND V(s2) AT 10
.meas ac g20 FIND mag(V(vout)) AT 20
.meas ac g30 FIND mag(V(vout)) AT 30
.meas ac g50 FIND mag(V(vout)) AT 50
.meas ac g100 FIND mag(V(vout)) AT 100
.meas ac g200 FIND mag(V(vout)) AT 200
.meas ac g500 FIND mag(V(vout)) AT 500
.meas ac g1k FIND mag(V(vout)) AT 1k
.meas ac g2k FIND mag(V(vout)) AT 2k
.meas ac g5k FIND mag(V(vout)) AT 5k
.meas ac g10k FIND mag(V(vout)) AT 10k
.meas ac g20k FIND mag(V(vout)) AT 20k
.end
