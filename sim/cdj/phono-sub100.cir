* PHONO v0.1 — ATTRIBUZIONE RESIDUO SUB-100 Hz (task phono-refine, 2026-09-30)
* Stessa catena di phono-riaa-ac.cir (Cload 200p fisso). Misura per blocco:
* s1 (A1 out) → s2 (SK out = rete RIAA in) → p (nodo uscita rete: Rr1 serie,
* Cr1 shunt, ramo Rr2+Cr2 verso p2 interno) → q (post 1 polo 15,9 Hz C3/Rb2)
* → vout (A5 out). Ipotesi: il polo C3 100n/Rb2 100k (a) attenua da solo e
* (b) interagisce con la Z Thevenin del nodo p, caricando la rete RIAA fuori
* dalle ipotesi delle sue equazioni (terminazione ideale).
* Lezione §5.4(5): una analisi per netlist → solo .ac qui.
.include ../lib/opamp-audio.inc
Vcc vcc 0 DC 15
Vee vee 0 DC -15
Vcart cart 0 DC 0 AC 1
Rcart cart in 660
Rload in 0 47k
Cload in 0 200p
* --- [A1] stadio 1 non-inv x21 ---
X1 in fb1 s1 vcc vee OP1612
Rg1 fb1 0 1k
Rf1 fb1 s1 20k
* --- [A2] Sallen-Key HP 2 poli 13 Hz Q 0,707 unity ---
Cs1 s1 n1 100n
Cs2 n1 s2a 100n
Rs1 n1 s2 86.6k
Rs2 s2a 0 174k
X2 s2a s2 s2 vcc vee OP1612
* --- [A3] rete RIAA passiva ---
Rr1 s2 p 21.8k
Cr1 p 0 34.8n
Rr2 p p2 3.16k
Cr2 p2 0 100n
* --- [A4] 1 polo 15,9 Hz + DC block (SOSPETTO) ---
* NB: come nell'originale phono-riaa-ac.cir: C3 da p (uscita rete), non da p2.
C3 p q 100n
Rb2 q 0 100k
* --- [A5] stadio 2 non-inv x60,6 ---
X3 q qn vout vcc vee OP1654
Rg2 qn 0 1k
Rf2 qn vout 59.6k
.ac dec 200 5 100k
.meas ac m_s1_10 FIND mag(V(s1)) AT 10
.meas ac m_s1_20 FIND mag(V(s1)) AT 20
.meas ac m_s1_30 FIND mag(V(s1)) AT 30
.meas ac m_s1_50 FIND mag(V(s1)) AT 50
.meas ac m_s1_100 FIND mag(V(s1)) AT 100
.meas ac m_s1_200 FIND mag(V(s1)) AT 200
.meas ac m_s1_1k FIND mag(V(s1)) AT 1k
.meas ac m_s2_10 FIND mag(V(s2)) AT 10
.meas ac m_s2_20 FIND mag(V(s2)) AT 20
.meas ac m_s2_30 FIND mag(V(s2)) AT 30
.meas ac m_s2_50 FIND mag(V(s2)) AT 50
.meas ac m_s2_100 FIND mag(V(s2)) AT 100
.meas ac m_s2_200 FIND mag(V(s2)) AT 200
.meas ac m_s2_1k FIND mag(V(s2)) AT 1k
.meas ac m_p_10 FIND mag(V(p)) AT 10
.meas ac m_p_20 FIND mag(V(p)) AT 20
.meas ac m_p_30 FIND mag(V(p)) AT 30
.meas ac m_p_50 FIND mag(V(p)) AT 50
.meas ac m_p_100 FIND mag(V(p)) AT 100
.meas ac m_p_200 FIND mag(V(p)) AT 200
.meas ac m_p_1k FIND mag(V(p)) AT 1k
.meas ac m_p2_10 FIND mag(V(p2)) AT 10
.meas ac m_p2_20 FIND mag(V(p2)) AT 20
.meas ac m_p2_30 FIND mag(V(p2)) AT 30
.meas ac m_p2_50 FIND mag(V(p2)) AT 50
.meas ac m_p2_100 FIND mag(V(p2)) AT 100
.meas ac m_p2_200 FIND mag(V(p2)) AT 200
.meas ac m_p2_1k FIND mag(V(p2)) AT 1k
.meas ac m_q_10 FIND mag(V(q)) AT 10
.meas ac m_q_20 FIND mag(V(q)) AT 20
.meas ac m_q_30 FIND mag(V(q)) AT 30
.meas ac m_q_50 FIND mag(V(q)) AT 50
.meas ac m_q_100 FIND mag(V(q)) AT 100
.meas ac m_q_200 FIND mag(V(q)) AT 200
.meas ac m_q_1k FIND mag(V(q)) AT 1k
.meas ac m_vout_10 FIND mag(V(vout)) AT 10
.meas ac m_vout_20 FIND mag(V(vout)) AT 20
.meas ac m_vout_30 FIND mag(V(vout)) AT 30
.meas ac m_vout_50 FIND mag(V(vout)) AT 50
.meas ac m_vout_100 FIND mag(V(vout)) AT 100
.meas ac m_vout_200 FIND mag(V(vout)) AT 200
.meas ac m_vout_1k FIND mag(V(vout)) AT 1k
.end
