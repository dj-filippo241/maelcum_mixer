* CANALE — FRONT-END PHONO MM v0.1: OVERLOAD E WARP (transiente)
* Caso 1 (step A=1): 1 kHz a livello di overload sheet (out +18 dBu →
*   in ≈ 48-50 mV): l'uscita deve restare pulita (clamp ±13,5 su ±15 LN).
* Caso 2 (step warp): warp 10 Hz sovrapposto a programma 1 kHz nominale:
*   warp 30/60/100 mV — si legge DOVE satura (stadio 1 / SK / stadio 2) e
*   il margine reale: la subsonica 3 ordini deve tenere lo stadio 2 fuori
*   dal clip fino a ~35 mV di warp a 10 Hz.
* Sonde: s1 (out stadio 1), s2 (out SK), vout (out blocco).
.include ../lib/opamp-audio.inc
Vcc vcc 0 DC 15
Vee vee 0 DC -15
* programma 1 kHz + warp 10 Hz IN SERIE (sorgente warp flottante)
Vsig sig 0 SINE(0 {A1k} 1000)
Rcart sig a 660
Vwarp a in SINE(0 {Aw} 10)
Rload in 0 47k
Cload in 0 200p
X1 in fb1 s1 vcc vee OP1612
Rg1 fb1 0 1k
Rf1 fb1 s1 20k
Cs1 s1 n1 100n
Cs2 n1 s2a 100n
Rs1 n1 s2 86.6k
Rs2 s2a 0 174k
X2 s2a s2 s2 vcc vee OP1612
Rr1 s2 p 21.8k
Cr1 p 0 34.8n
Rr2 p p2 3.16k
Cr2 p2 0 100n
X3 p qn vout vcc vee OP1654
Rg2 qn 0 1k
Rf2 qn vout 59.6k
.step param Aw LIST 0 0.03 0.06 0.1
.param A1k=0.005
.tran 0 1.2 0.8 20u
.meas tran s1_pk MAX ABS(V(s1))
.meas tran s2_pk MAX ABS(V(s2))
.meas tran out_pk MAX ABS(V(vout))
.end
