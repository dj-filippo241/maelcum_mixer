* CDJ §7 item 2 — THAT 218x: headroom a +18 dBu (worst user error, sheet §2)
* Caso 1: GAIN 0 dB (detent) → margine sul clamp del macro (±16,5 V).
* Caso 2: GAIN +10 dB su +18 dBu = +28 dBu: VIOLAZIONE della regola K4
* (in × gain ≤ +23): il clamp a ±16,5 V = saturazione; documentato come
* comportamento in user-error (non è un guasto del design).
* THD vs livello: NON misurabile in macro lineare — datasheet 0,0025-0,005%
* a −5 dBV; al prototipo modello TI reale + banco (stesso trattamento di
* eq-serie §9.7).
.include ../lib/that2181.inc
.param gcase=0
Vcc vcc 0 DC 18
Vee vee 0 DC -18
* +18 dBu = 6,15 Vrms = 8,70 Vp, 1 kHz
V1 in 0 SINE(0 8.7 1k)
Becp ecp 0 V={gcase*6.1m}
Becm ecm 0 V=0
X1 in out ecp ecm vcc vee THAT2181
.step param gcase LIST 0 10
.tran 0 4m 0 1u
.meas tran vinpk MAX ABS(V(in))
.meas tran voutpk MAX ABS(V(out))
.end
