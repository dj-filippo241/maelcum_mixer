* Lickshot - guadagno del giro con la make-up corretta (rmk 47k, uscite BBD 100k):
* ricerca del valore di taratura (rmkf) per SUM -> POST = 1 (0 dB).
* Si inietta 1 V AC al capo della reazione (fbx) e si legge FB: |V(fb)| a 1 kHz
* = guadagno del giro. v0.2 (op-amp ideali, giro-att14.cir): 1,1 x rip.
* Diodi a riposo (piccolo segnale): la saturazione non lavora.
.param vol=1 rip=1 eco=0 tc=0.5 ilg=1 td=50m rbo=1k rlb=100k rmk=47k rmkf=250k
.include scheda.inc
Vvco vcoout 0 0
.param hold=0
Vt fbx vmid AC 1
* carico della reazione: 10k verso la massa virtuale della somma
Rfbl fb vmid 10k
.step param rmkf list 100k 250k 270k 600k
.step param tc list 0.05 0.5
.step param ilg list 0.63 1 1.58
.ac dec 20 100 10k
.meas ac g_giro FIND mag(V(fb)) AT 1k
.meas ac g_bbd FIND mag(V(bbd1out)/V(att,vmid)) AT 1k
.meas ac g_mk FIND mag(V(post,vmid)/V(sum,vmid)) AT 1k
.meas ac g_rip FIND mag(V(fb,vmid)/V(gy,vmid)) AT 1k
.end
