* Lickshot - giro dell'eco della scheda corretta (.tran), come giro-att14.cir ma
* con gli stadi veri: colpo dall'uscita quadra del CD4046 (0/9 V, 600 Hz) via
* passa-alto e guadagno 1,91, FIRE premuto {hold} s, VOLUME tutto, LIVELLO ECO 0.
* Make-up tarata (rmkf 275k con un BBD, dec. 198: SUM -> POST ~ +0,8 dB di giro, scheda-anello-47k.cir).
.param vol=1 rip=1 eco=0 tc=0.5 ilg=1 td=50m rbo=1k rlb=100k rmk=47k rmkf=275k hold=0.2
.include scheda.inc
Vvco vcoout 0 PULSE(0 9 0 1u 1u 0.832m 1.6667m)
Rlink fb fbx 1m
.step param rip list 0.5 0.9 1
.tran 0 1.5 0 20u
.meas tran dry_pk MAX abs(V(dry)-V(vmid)) FROM 0.05 TO 0.2
.meas tran bbd_pk MAX abs(V(bbd1in)-2.5) FROM 0.05 TO 1.5
.meas tran sum_pk MAX abs(V(sum)-V(vmid)) FROM 0.05 TO 1.5
.meas tran post_pk MAX abs(V(post)-V(vmid)) FROM 0.05 TO 1.5
.meas tran fb_pk MAX abs(V(fb)-V(vmid)) FROM 0.05 TO 1.5
.meas tran fb_coda MAX abs(V(fb)-V(vmid)) FROM 1.3 TO 1.5
.meas tran sum_max MAX V(sum) FROM 0.05 TO 1.5
.meas tran sum_min MIN V(sum) FROM 0.05 TO 1.5
.end
