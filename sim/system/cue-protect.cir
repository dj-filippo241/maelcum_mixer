* PROTEZIONE del CUE [G] (sistema-cue.md §6; pcb/cue/NOTE.md punti 6-7; todo 298) - tempi.
* Circuito come pcb/cue/cue.py, blocco [G]:
*  - VREF: TL431 da +5 V attraverso 1k (shunt a 2,495 V, modello a soglia con carico vero).
*  - finestre positive: RAW+22 160k/27k4 (17,06 V), RAW+27 160k/22k6 (20,16 V), contro VREF.
*  - finestre negative: partitore fra VREF e il raw (10k/120k e 10k/140k), contro THN =
*    VREF x 10k/25k = 1,00 V; il nodo sale quando il raw cala. BAT54 a massa sui due nodi.
*  - quattro uscite LM339 open collector in OR su ROK (pull-up 10k); timer RT 1M2, CT 2u2,
*    BAT54 da CT a ROK (scarica); LM339 del timer: CT contro VREF -> KG0 (pull-up 10k).
*  - KG0 -> 100 -> gate AO3400 -> due G6K-2F 5 V (237 ohm, 3 ms max di rilascio) + 1N4148W.
* LM339 = interruttore senza isteresi (Vh 1 mV solo per il solutore); sotto +5 = 2 V
* l'uscita e' aperta (caso peggiore: KG0 tirato su dal pull-up).
* Rail a valle (solo lettura): +-18 = LM317/337 dal raw +-27 (dropout 1,7 V);
* +-15 LN = LM317/337 a +-16,5 (dropout 1,6 V) poi LT3045/3094 (0,15 V).
* Sequenza (param ord: 0 = +5 per primo, 1 = +5 per ultimo):
*  accensione: +5 in 50 ms; raw +-27 (rete) in 30 ms da 0,05 s, ripple 100 Hz 0,3 Vpp;
*  +-22 (LDO del box, soft start) a 0,15 s.
*  3,000 s: guasto del -22 (sale a -15 V per 20 ms) -> apertura e riarmo.
*  6,000 s: guasto del +27 (scende a 19 V per 20 ms) -> apertura.
*  9,000 s: spegnimento. +-27 calano da subito (0,17 A su 5,9 mF = 29 V/s);
*  +-22 tengono 25,9 ms (rete -10 %, psu-esterno §2.6) poi calano a s22 V/ms
*  (0,16 = 2,7 A del ramo audio, dec. 131, su 15 + 2,2 mF; 1 = caso del mute-ctrl del master);
*  +5 tiene 60 ms, poi cade in 40 ms.
.param kC=1 ord=0 s22=1 Lc=0.15 Rc=237 Ion={2*5/Rc}
.step param kC list 0.8 0.9 1 1.1
.step param s22 list 0.16 1
.step param ord list 0 1
.model D1N4148 D(Is=2.52n Rs=0.568 N=1.752 Cjo=4p Tt=4n)
.model BAT54 D(Is=0.1u Rs=1.5 N=1.0 Cjo=10p BV=30)
.model SWC SW(Ron=50 Roff=100Meg Vt=0 Vh=1m)
.model AO3400 VDMOS(Vto=1.05 Kp=12 Rd=0.015 Rs=0.01 Cgdmax=150p Cgdmin=20p Cgs=600p)
.subckt CMP inp inm out vcc
Bc c 0 V=if(V(vcc)>2, V(inm)-V(inp), -1)
S1 out 0 c 0 SWC
.ends
* ---------------- alimentazioni
Vp5a p5a 0 PWL(0 0 50m 5 9.06 5 9.1 0)
Vp5b p5b 0 PWL(0 0 0.3 0 0.35 5 9.06 5 9.1 0)
Bp5 p5s 0 V=if(ord>0.5, V(p5b), V(p5a))
Rp5 p5s p5 0.05
Cp5 p5 0 47u
* raw +-27: inviluppo + ripple (solo con l'inviluppo sopra 1 V)
Ve27 e27 0 PWL(0 0 0.05 0 0.08 27.5 6 27.5 6.0001 19 6.02 19 6.0201 27.5 9 27.5 9.6 10)
Bp27 r27p 0 V=V(e27)+if(V(e27)>1, 0.15*sin(2*pi*100*time), 0)
Ve27n e27n 0 PWL(0 0 0.05 0 0.08 27.5 9 27.5 9.6 10)
Bn27 r27n 0 V=-(V(e27n)+if(V(e27n)>1, 0.15*sin(2*pi*100*time+1), 0))
* +-22 (LDO del box)
.param toff={9.0259} tend={9.0259+22/s22/1000}
Vp22 r22p 0 PWL(0 0 0.15 0 0.16 22 {toff} 22 {tend} 0)
Vn22 r22n 0 PWL(0 0 0.15 0 0.16 -22 3 -22 3.0001 -15 3.02 -15 3.0201 -22 {toff} -22 {tend} 0)
* rail a valle (lettura)
Bp18 p18 0 V=max(0,min(18, V(r27p)-1.7))
Bn18 n18 0 V=min(0,max(-18, V(r27n)+1.7))
Bp15 p15 0 V=max(0,min(15, min(16.5, V(r22p)-1.6)-0.15))
Bn15 n15 0 V=min(0,max(-15, max(-16.5, V(r22n)+1.6)+0.15))
* ---------------- VREF (TL431, 2,495 V)
Rref p5 vref 1k
Bsh vref 0 I=if(V(vref)>2.495, (V(vref)-2.495)*1000, 0)
* ---------------- finestre
Rd22a r22p d22 160k
Rd22b d22 0 27.4k
Rd27a r27p d27 160k
Rd27b d27 0 22.6k
Rth1 vref thn 15k
Rth2 thn 0 10k
Rn22a vref n22 10k
Rn22b n22 r22n 120k
Rn27a vref n27 10k
Rn27b n27 r27n 140k
Dc22 0 n22 BAT54
Dc27 0 n27 BAT54
* LM339 U6: uscita bassa quando inm > inp
Xc1 d22 vref rok p5 CMP
Xc2 d27 vref rok p5 CMP
Xc3 thn n22 rok p5 CMP
Xc4 thn n27 rok p5 CMP
Rrok rok p5 10k
* ---------------- timer
RT rok ct 1.2Meg
CT ct 0 {2.2u*kC}
DT ct rok BAT54
Xc5 ct vref kg0 p5 CMP
Rkg0 kg0 p5 10k
* ---------------- driver e relè (due G6K-2F in parallelo)
Rg kg0 kg 100
M1 kd kg 0 0 AO3400
Lk p5 xk {Lc/2}
Rk xk kd {Rc/2}
Dk kd p5 D1N4148
.tran 0 9.3 0 0.2m
* accensione: ultima condizione in finestra = +22 a 0,158 s (ord 0) o +5 a 0,33 s (ord 1)
.meas tran t_last  PARAM if(ord>0.5, 0.3+0.05*2.1/5, 0.15+0.01*17.06/22)
.meas tran d_on    PARAM t_on-t_last
.meas tran t_on   WHEN I(Lk)={0.75*Ion} RISE=1
.meas tran i_glitch MAX I(Lk) FROM 0 TO 1.2
.meas tran i_on   AVG I(Lk) FROM 2.5 TO 2.9
* guasto del -22 a 3,000 s
.meas tran t_trip22  WHEN V(rok)=2 TD=2.9 FALL=1
.meas tran d_trip22  PARAM t_trip22-3.0
.meas tran t_coil22  WHEN I(Lk)={0.1*Ion} TD=2.9 FALL=1
.meas tran d_open22  PARAM t_coil22-3.0+3m
.meas tran t_re22    WHEN I(Lk)={0.75*Ion} TD=3.03 RISE=1
.meas tran d_riarmo22 PARAM t_re22-3.02
* guasto del +27 a 6,000 s (sotto 20,16 V quando la rampa passa: ~6,00003 s)
.meas tran t_trip27  WHEN V(rok)=2 TD=5.9 FALL=1
.meas tran t_coil27  WHEN I(Lk)={0.1*Ion} TD=5.9 FALL=1
.meas tran d_open27  PARAM t_coil27-6.0+3m
* spegnimento a 9,000 s
.meas tran t_tripoff WHEN V(rok)=2 TD=8.9 FALL=1
.meas tran r22_trip  FIND V(r22p) AT t_tripoff
.meas tran t_coiloff WHEN I(Lk)={0.1*Ion} TD=8.9 FALL=1
.meas tran t_contoff PARAM t_coiloff+3m
.meas tran d_contoff PARAM t_contoff-9.0
.meas tran p15_cont  FIND V(p15) AT t_contoff
.meas tran n15_cont  FIND V(n15) AT t_contoff
.meas tran p18_cont  FIND V(p18) AT t_contoff
.meas tran n18_cont  FIND V(n18) AT t_contoff
* nodi negativi e LM339: mai sotto -0,3 V
.meas tran n22_min MIN V(n22)
.meas tran n27_min MIN V(n27)
.meas tran d27_max MAX V(d27) FROM 1 TO 2
.meas tran vref_on AVG V(vref) FROM 2 TO 2.5
.meas tran i_after MAX I(Lk) FROM 9.2 TO 9.3
.end
