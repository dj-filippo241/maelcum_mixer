* S1 REV 2026-10-13 — raddrizzatore con trasformatore REALE: EMF a vuoto =
* Vnom*(1+reg), R equivalente = reg*Vnom/Inom per meta' avvolgimento.
* Casi (.step k): Vnom, Inom, regolazione, fattore rete, Idc per ramo.
.param k=1
.param vs=table(k,1,20,2,20,3,20,4,20,5,20) ir=table(k,1,0.3,2,0.3,3,0.4,4,0.4,5,0.4) reg=table(k,1,0.14,2,0.14,3,0.12,4,0.12,5,0.12) mf=table(k,1,0.9,2,1.0,3,0.9,4,1.0,5,1.1) idc=table(k,1,0.17,2,0.13,3,0.17,4,0.13,5,0.13)
.param rw={reg*vs/ir} vpk={vs*(1+reg)*mf*1.4142}
.model DR D(Is=5n Rs=0.03 N=1.6)
Va a ct SINE(0 {vpk} 50)
Vb ct b SINE(0 {vpk} 50)
Vct ct 0 0
Rwa a a1 {rw}
Rwb b b1 {rw}
D1 a1 vp DR
D2 b1 vp DR
D3 vn a1 DR
D4 vn b1 DR
C1 vp 0 4.7m ic=20
C2 0 vn 4.7m ic=20
I1 vp 0 {idc}
I2 0 vn {idc}
.step param k 1 5 1
.tran 0 1.0 0.6 100u uic
.meas tran irms RMS I(Rwa)
.meas tran vdc AVG V(vp)
.meas tran vmin MIN V(vp)
.meas tran vmax MAX V(vp)
.end
