* ============================================================
* S5 CUE - Test 1: ampli cuffia su carichi reali (cue-hp-load)
* Riferimento: sistema-cue.md par. 5, ampli cuffia v0.2 (redesign
* 2026-10-12). La v0.1 (op-amp sul nodo base del Vbe-multiplier,
* limitatori senza resistenza di pilotaggio, nessuna compensazione)
* oscillava a burst ai passaggi per lo zero: vedi RISULTATI-cue.md
* Test 1 REV 2. Storia dei netlist v0.1: git (commit ca0f103).
* Carichi: 32 / 250 / 16 (2x32 par) / 25,8 (32+250 par) / corto
* 0,01. Ampiezza 1,414 Vp (1 Vrms, requisito) e 12 Vp (limite).
* errpk = max |OUTA - IN|: rivelatore diretto di oscillazione (deve
* stare nei mV a 1 Vrms). THD: leggere SEMPRE Partial E Total; se
* Total >> Partial c'e' contenuto non armonico (RF), non crossover.
* ============================================================
.inc ../lib/opamp-audio.inc

* ---------- modelli discreti (pattern compB-swing.cir) ----------
.model MJE340 NPN(IS=1e-13 BF=150 VAF=150 IKF=0.5 BR=5 CJC=4p CJE=15p TF=2n TR=20n RB=5 RC=1 RE=0.1 Vceo=300 Icrating=500m mfg=ON)
.model MJE350 PNP(IS=1e-13 BF=100 VAF=120 IKF=0.4 BR=3 CJC=4p CJE=15p TF=5n TR=20n RB=5 RC=1.5 RE=0.15 Vceo=300 Icrating=500m mfg=ON)
.model QSM NPN(IS=1e-14 BF=250 CJC=4p CJE=8p TF=10n)
.model QSM2 PNP(IS=1e-14 BF=100 CJC=4p CJE=8p TF=10n)
.model QSM3 NPN(IS=1e-14 BF=100 CJC=4p CJE=8p TF=10n)
.model JCRD NJF(VTO=-2.0 BETA=2.0m LAMBDA=0.02)

* ---------- alimentazioni ----------
Vp vp 0 18
Vm vm 0 -18

* ---------- ampli cuffia v0.2 ----------
* PIN BJT = C-B-E (lezione 5 RISULTATI-cue).
* Anello: OP1612 gain +1, feedback DC da OUTA via Rf, compensazione
* Cf uscita op-amp -> ingresso invertente (crossover anello esterno
* 1/(2*pi*Rf*Cf) ~ 1 MHz: l'op-amp non insegue il buffer a 80 MHz).
XU1 in fbu uo vp vm OP1612
Rf outa fbu {RF}
Cf uo fbu {CF}
* Rdrv: isola l'op-amp dalla rete di bias e FISSA la corrente che i
* limitatori devono vincere ((16,5 V - Vout)/Rdrv ~ 16 mA in corto).
Rdrv uo nb {RDRV}
* Vbe-multiplier VERO tra pb e nb (C=pb, B=tap, E=nb), trimmer TR
* in serie a Ra, bypass Cb: le due basi vedono lo stesso pilotaggio.
Qm pb tap nb QSM
Ra pb tap {1000+TR}
Rb tap nb 1000
Cb pb nb {CB}
* CCS JFET (CRD Idss ~8 mA) sopra e sotto la stringa
J1 vp pb pb JCRD
J2 nb vm vm JCRD
* base stopper + finali
Rbn pb bn {RBS}
Rbp nb bp {RBS}
Q1 vp bn en MJE340
Q2 vm bp ep MJE350
Vam en en2 0
Ren en2 outa {RE}
Rep ep outa {RE}
* limitatori Vbe sui Re con resistenza di base 100 ohm
* NPN c=pb b=capo alto Ren e=OUTA ; PNP c=nb b=capo basso Rep e=OUTA
Rln en bln 100
Qln pb bln outa QSM3
Rlp ep blp 100
Qlp nb blp outa QSM2
* ---------- uscita: Rserie fuori anello + jack + carico ----------
Rser outa jack 10
Rload jack 0 {RL}
.param RF=470 CF=330p RDRV=1k CB=1u RBS=22 RE=6.8 TR=210

* ---------- analisi ----------
V1 in 0 sine 0 {VA} 1k
.step param RL list 32 250 16 25.8 0.01
.step param VA list 1.414 12
.options plotwinsize=0
.save V(jack) V(outa) V(in) V(uo) V(vp) V(en) I(Vam) I(Vp) I(Rser) Ic(Q1)
.tran 0 5m 2m 50n
.four 1k 9 3 V(jack)
.meas tran errpk MAX abs(V(outa)-V(in))
.meas tran vjpk MAX V(jack)
.meas tran vjmin MIN V(jack)
.meas tran iserpk MAX I(Rser)
.meas tran isermin MIN I(Rser)
.meas tran pq1 AVG (V(vp)-V(en))*Ic(Q1)
.end
