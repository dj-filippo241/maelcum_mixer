* S1 REV 2026-10-13 — raddrizzatore con trasformatore REALE: EMF a vuoto =
* Vnom*(1+reg), R equivalente = reg*Vnom/Inom per meta' avvolgimento.
* Casi (.step k): Vnom, Inom, regolazione, fattore rete, Idc per ramo.
.param k=1
.param vs=table(k,1,8,2,8,3,9,4,9,5,9) ir=table(k,1,1.2,2,1.2,3,2.0,4,2.0,5,2.0) reg=table(k,1,0.12,2,0.12,3,0.1,4,0.1,5,0.1) mf=table(k,1,0.9,2,1.0,3,0.9,4,1.0,5,1.1) idc=table(k,1,1.0,2,0.55,3,1.0,4,0.55,5,0.4)
.param rw={reg*vs/ir} vpk={vs*(1+reg)*mf*1.4142}
.model DR D(Is=5n Rs=0.03 N=1.6)
Va a b SINE(0 {vpk} 50)
Rga a 0 1Meg
Rgb b 0 1Meg
Rwa a a1 {rw}
D1 a1 vp DR
D2 b vp DR
D3 0 a1 DR
D4 0 b DR
C1 vp 0 10m ic=8
I1 vp 0 {idc}
.step param k 1 5 1
.tran 0 1.0 0.6 100u uic
.meas tran irms RMS I(Rwa)
.meas tran vdc AVG V(vp)
.meas tran vmin MIN V(vp)
.meas tran vmax MAX V(vp)
.end
