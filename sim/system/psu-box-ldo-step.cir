* PSU esterna (todo 51): LDO discreto +-22,5 V da raw fisso 25 V (rampa 1 ms). Gradino di carico 1,0 -> 1,7 A a 80 ms.
* Errore d'amplificatore: macro comportamentale inline (solo .tran), A0 100 dB, GBW ~1 MHz,
* uscita limitata a 1,5 V dai rail. Soft-start: riferimento con RC (tau ~0,1 s).
.param idc=1.7
.model DR D(Is=5n Rs=0.03 N=1.6)
.model DZ12 D(Is=1p Rs=5 BV=12 IBV=1m)
.model DZ25 D(Is=1p Rs=2 BV=2.5 IBV=1m)
.model QN NPN(Is=1f Bf=150 Vaf=80 Cjc=5p Cje=10p Tf=1n)
.model QP PNP(Is=1f Bf=150 Vaf=80 Cjc=5p Cje=10p Tf=1n)
.model MP VDMOS(pchan Vto=-3.5 Kp=8 Rd=0.06 Rs=0.02 Cgdmax=1n Cgdmin=0.2n Cgs=1.5n Cjo=1n)
.model MN VDMOS(Vto=3.5 Kp=8 Rd=0.06 Rs=0.02 Cgdmax=1n Cgdmin=0.2n Cgs=1.5n Cjo=1n)
.subckt EA inp inn out vp vm
* transconduttanza lineare + polo dominante: A0 = 1e5, GBW ~1 MHz; clamp a diodi 1,5 V dai rail
G1 0 y inp inn 1m
Ry y 0 100Meg
Cy y 0 159p
Vch vp hi 1.5
Vcl lo vm 1.5
Dch y hi DCL
Dcl lo y DCL
.model DCL D(Is=1f N=1)
E1 o 0 y 0 1
Ro o out 100
.ends
Vp vp 0 PWL(0 0 1m 25)
Vn 0 vn PWL(0 0 1m 25)
* --- ramo positivo ---
Rsp vp sp 0.22
Qlp g1 sp vp QP
M1 op g1 sp MP
Rgs1 sp g1 10k
Dz1 g1 sp DZ12
Qd1 g1 bd1 ed1 QN
Re1 ed1 0 4.7k
Rbd1 ea1 bd1 1k
Rr1 vp r1 10k
Dr1 0 r1 DZ25
Rss1 r1 ref1 100k
Css1 ref1 0 1n
R11 op fb1 39.9k
R21 fb1 0 4.99k
XE1 ref1 fb1 ea1 vp 0 EA
Cc1 ea1 cz1 10n
Rz1 cz1 fb1 10k
Cop op 0 470u Rser=0.05
* --- ramo negativo (specchio) ---
Rsn sn vn 0.22
Qln g2 sn vn QN
M2 on g2 sn MN
Rgs2 g2 sn 10k
Dz2 sn g2 DZ12
Qd2 g2 bd2 ed2 QP
Re2 0 ed2 4.7k
Rbd2 ea2 bd2 1k
Rr2 r2 vn 10k
Dr2 r2 0 DZ25
Rss2 r2 ref2 100k
Css2 ref2 0 1n
R12 on fb2 39.9k
R22 fb2 0 4.99k
XE2 ref2 fb2 ea2 0 vn EA
Cc2 ea2 cz2 10n
Rz2 cz2 fb2 10k
Con 0 on 470u Rser=0.05
* --- cavo 2 m: 2 x 0,5 mm2 per polo (0,036 ohm/m) ---
Rcp op cp 0.036
Lcp cp mp 1u
Rcn on cn 0.036
Lcn cn mn 1u
Cmp mp 0 2.2m Rser=0.03
Cmn 0 mn 2.2m Rser=0.03
I1 mp 0 PWL(0 0 2m 0 2.1m 1.0 80m 1.0 80.01m 1.7)
I2 0 mn PWL(0 0 2m 0 2.1m 1.0 80m 1.0 80.01m 1.7)
.tran 0 100m 0 1u
.meas tran v1 AVG V(mp) FROM 70m TO 80m
.meas tran pp1 PP V(mp) FROM 70m TO 80m
.meas tran vmin MIN V(mp) FROM 80m TO 82m
.meas tran vmax MAX V(mp) FROM 80m TO 82m
.meas tran v2 AVG V(mp) FROM 95m TO 100m
.meas tran pp2 PP V(mp) FROM 90m TO 100m
.meas tran vn2 AVG V(mn) FROM 95m TO 100m
.meas tran ppn PP V(mn) FROM 90m TO 100m
.meas tran vnmin MAX V(mn) FROM 80m TO 82m
.end
