* S1 REV 2026-10-14 (dec. 111, todo 47): ramo audio con i moduli opzionali predisposti
* (EQ grafico su due inserzioni ~100 mA + uscite per via ~150 mA + margine): ~1,7 A per ramo.
* Casi: 1 avvolgimento attuale 2x21 V 3,0 A a rete -10 %; 2 candidato 3,5 A a rete -10 %;
* 3 candidato 4,0 A a rete -10 %; 4-5 candidati 3,5 / 4,0 A a rete +10 % con carico leggero 1,0 A.
* Requisito: Vmin >= 21,7 V (LM317 -> 19,2 V). Corrente efficace d'avvolgimento ~1,9x la DC.
.param k=1
.param vs=21 ir=table(k,1,3.0,2,3.5,3,4.0,4,3.5,5,4.0) reg=0.07 mf=table(k,1,0.9,2,0.9,3,0.9,4,1.1,5,1.1) idc=table(k,1,1.7,2,1.7,3,1.7,4,1.0,5,1.0)
.param rw={reg*vs/ir} vpk={vs*(1+reg)*mf*1.4142}
.model DR D(Is=5n Rs=0.03 N=1.6)
Va a ct SINE(0 {vpk} 50)
Vb ct b SINE(0 {vpk} 50)
Vct ct 0 0
Rwa a a1 {rw}
Rwb b b1 {rw}
D1 a1 vp DR
D2 b1 vp DR
D3 vn a1 DR
D4 vn b1 DR
C1 vp 0 10m ic=20
C2 0 vn 10m ic=20
I1 vp 0 {idc}
I2 0 vn {idc}
.step param k 1 5 1
.tran 0 1.0 0.6 100u uic
.meas tran irms RMS I(Rwa)
.meas tran vdc AVG V(vp)
.meas tran vmin MIN V(vp)
.meas tran vmax MAX V(vp)
.end
