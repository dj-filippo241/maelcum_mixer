* PSU esterna (todo 51): SPEGNIMENTO. Rete staccata a t = 1,2 s (fase peggiore: subito dopo un picco).
* Domanda: quanto tempo resta prima che i regolatori locali dei moduli (LM317 -> 19,2 V, chiedono
* >= 20,9 V) escano di regolazione, e quanto ci mette il rivelatore AC_OK a dare l'allarme.
* AC_OK: doppia semionda dal W1 (stesso toroidale del W4), partitore, picco su RC tau 43 ms,
* soglia 70 % del picco nominale. Carico costante (caso peggiore: niente calo di corrente).
* Variante: bulk W1 10 mF contro 15 mF. Casi: 1 rete -10 % 10 mF | 2 rete -10 % 15 mF | 3 rete +10 % 15 mF (ripple, calore). Tutti 1,7 A.
.param k=1
.param cb=table(k,1,10m,2,15m,3,15m)
.param mf=table(k,1,0.9,2,0.9,3,1.1) idc=table(k,1,1.7,2,1.7,3,1.7)
.param vs=21 ir=3.5 reg=0.07
.param rw={reg*vs/ir} vpk={vs*(1+reg)*mf*1.4142}
.model DR D(Is=5n Rs=0.03 N=1.6)
.model DZ12 D(Is=1p Rs=5 BV=12 IBV=1m)
.model DZ25 D(Is=1p Rs=2 BV=2.5 IBV=1m)
.model QN NPN(Is=1f Bf=150 Vaf=80 Cjc=5p Cje=10p Tf=1n)
.model QP PNP(Is=1f Bf=150 Vaf=80 Cjc=5p Cje=10p Tf=1n)
.model MP VDMOS(pchan Vto=-3.5 Kp=8 Rd=0.06 Rs=0.02 Cgdmax=1n Cgdmin=0.2n Cgs=1.5n Cjo=1n)
.model MN VDMOS(Vto=3.5 Kp=8 Rd=0.06 Rs=0.02 Cgdmax=1n Cgdmin=0.2n Cgs=1.5n Cjo=1n)
.subckt EA inp inn out vp vm
* transconduttanza lineare + polo dominante: A0 = 1e5, GBW ~1 MHz; clamp a diodi 1,5 V dai rail
G1 0 y inp inn 1m
Ry y 0 100Meg
Cy y 0 159p
Vch vp hi 1.5
Vcl lo vm 1.5
Dch y hi DCL
Dcl lo y DCL
.model DCL D(Is=1f N=1)
E1 o 0 y 0 1
Ro o out 100
.ends
* --- trasformatore e ponte ---
Ba a ct V={vpk}*sin(2*pi*50*time+pi/2)*(time<1.2)
Bb ct b V={vpk}*sin(2*pi*50*time+pi/2)*(time<1.2)
* rivelatore AC_OK
Da1 a ac1 DR
Da2 b ac1 DR
Ra1 ac1 acd 47k
Ra2 acd 0 4.7k
Ca acd 0 10u

Vct ct 0 0
Rwa a a1 {rw}
Rwb b b1 {rw}
D1 a1 vp DR
D2 b1 vp DR
D3 vn a1 DR
D4 vn b1 DR
C1 vp 0 {cb}
C2 0 vn {cb}
* --- ramo positivo ---
Rsp vp sp 0.22
Qlp g1 sp vp QP
M1 op g1 sp MP
Rgs1 sp g1 10k
Dz1 g1 sp DZ12
Qd1 g1 bd1 ed1 QN
Re1 ed1 0 4.7k
Rbd1 ea1 bd1 1k
Rr1 vp r1 10k
Dr1 0 r1 DZ25
Rss1 r1 ref1 100k
Css1 ref1 0 1u
R11 op fb1 38.3k
R21 fb1 0 4.99k
XE1 ref1 fb1 ea1 vp 0 EA
Cc1 ea1 cz1 10n
Rz1 cz1 fb1 10k
Cop op 0 470u Rser=0.05
* --- ramo negativo (specchio) ---
Rsn sn vn 0.22
Qln g2 sn vn QN
M2 on g2 sn MN
Rgs2 g2 sn 10k
Dz2 sn g2 DZ12
Qd2 g2 bd2 ed2 QP
Re2 0 ed2 4.7k
Rbd2 ea2 bd2 1k
Rr2 r2 vn 10k
Dr2 r2 0 DZ25
Rss2 r2 ref2 100k
Css2 ref2 0 1u
R12 on fb2 38.3k
R22 fb2 0 4.99k
XE2 ref2 fb2 ea2 0 vn EA
Cc2 ea2 cz2 10n
Rz2 cz2 fb2 10k
Con 0 on 470u Rser=0.05
* --- cavo 2 m: 2 x 0,5 mm2 per polo (0,036 ohm/m) ---
Rcp op cp 0.036
Lcp cp mp 1u
Rcn on cn 0.036
Lcn cn mn 1u
Cmp mp 0 2.2m Rser=0.03
Cmn 0 mn 2.2m Rser=0.03
I1 mp 0 PWL(0 0 0.3 0 0.4 {idc})
I2 0 mn PWL(0 0 0.3 0 0.4 {idc})

.step param k 1 3 1
.tran 0 1.35 0 50u
.meas tran acpk MAX V(acd) FROM 1.1 TO 1.2
.meas tran acmin MIN V(acd) FROM 1.1 TO 1.2
.meas tran t_ac WHEN V(acd)=0.7*acpk TD=1.2 FALL=1
.meas tran t_ldo WHEN V(mp)=21.5 TD=1.2 FALL=1
.meas tran t_loc WHEN V(mp)=20.9 TD=1.2 FALL=1
.meas tran dt_ac PARAM t_ac-1.2
.meas tran dt_ldo PARAM t_ldo-1.2
.meas tran vraw_min MIN V(vp) FROM 1.1 TO 1.2
.meas tran irms_w RMS I(Rwa) FROM 1.0 TO 1.2
.meas tran dt_loc PARAM t_loc-1.2
.end
