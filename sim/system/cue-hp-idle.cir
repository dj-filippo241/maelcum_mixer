* ============================================================
* S5 CUE — Test 5: idle del diamond vs trimmer e temperatura
* (cue-hp-idle, task sistema-cue-banco 2026-10-02)
* Trimmer nel Vbe-multiplier: Ra = 1k fisso + TR (trimmer 500 ohm,
* corso utile 0-400). Idle = (Vmult − 2·Vbe)/(2·Re 4,7).
* .step temp: multiplier e pass sulla STESSA aletta (assunzione di
* design): il tracking Vbe dovrebbe tenere l'idle quasi costante.
* Letture: I(Ren) DC = idle per ramo; THD a 1 Vrms/32 ohm al set
* nominale TR=200 per ogni temperatura (crossover pulito?).
* ============================================================
.inc ../lib/opamp-audio.inc

* ---------- modelli discreti (pattern compB-swing.cir) ----------
.model MJE340 NPN(IS=1e-13 BF=150 VAF=150 IKF=0.5 BR=5 CJC=4p CJE=15p TF=2n TR=20n RB=5 RC=1 RE=0.1 Vceo=300 Icrating=500m mfg=ON)
.model MJE350 PNP(IS=1e-13 BF=100 VAF=120 IKF=0.4 BR=3 CJC=4p CJE=15p TF=5n TR=20n RB=5 RC=1.5 RE=0.15 Vceo=300 Icrating=500m mfg=ON)
.model QSM NPN(IS=1e-14 BF=250 CJC=4p CJE=8p TF=10n)

* ---------- alimentazioni ----------
Vp vp 0 18
Vm vm 0 -18

* ---------- ingresso (level pot al massimo = sorgente diretta) ----------
V1 in 0 sine 0 1.414 1k

* ---------- OP1612 + diamond ----------
XU1 in fbu uo vp vm OP1612
* Vbe multiplier: Vmult = Vbe*(1+Ra/Rb) ~ 1,46 V -> idle ~20 mA su Re 4,7
* Stringa di bias pilotata da CCS JFET (CRD, Idss ~8 mA) e NON da
* resistore al rail: col resistore la corrente di stringa crollava a
* uscita alta (18-12,7)/2k2 = 2,4 mA -> crossover = THD 5-57% misurata
Qm pb bm nb QSM
Rdrv uo bm 0.001
Ra pb bm {1000+TR}
Rb bm nb 1000
J1 vp pb pb JCRD
J2 nb vm vm JCRD
.model JCRD NJF(VTO=-2.0 BETA=2.0m LAMBDA=0.02)
Q1 vp pb en MJE340
Q2 vm nb ep MJE350
Vam en en2 0
Ren en2 outa 4.7
Rep ep outa 4.7
* limitatori di corrente sui Re (0,65 V / 4,7 = 138 mA)
Qln pb en outa QSM3
Qlp nb ep outa QSM2
.model QSM2 PNP(IS=1e-14 BF=100)
.model QSM3 NPN(IS=1e-14 BF=100)
* feedback unity diretto da OUTA (pre-Rserie: stabilita' su carico
* capacitivo; la Rserie resta fuori anello = Zout 10 ohm al jack)
Rfb1 fbu outa 0.001

* ---------- uscita: Rserie + jack + carico ----------
Rser outa jack 10
Rload jack 0 32

.param TR=200
.step param TR LIST 0 200 400
.step temp LIST 27 50 75
.op
.tran 0 12m 4m 5u
.meas tran idle AVG I(Vam)
.four 1k 9 8 V(jack)
.end
