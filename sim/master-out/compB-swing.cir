* ============================================================
* MASTER OUT v0.3-WIP — composito v0.2 + BOOTSTRAP rail OPA1612
* Test 1: swing massimo (requisito +24 dBu = 17,4 Vp; target ±21)
* Riferimento: decisione 86, master-out.md ADDENDUM 2026-09-29
* ============================================================
* Topologia: composito v0.2 INVARIATO (OPAMAC 2 poli + diamond class AB,
* feedback unity a −in), ma i rail dell'op-amp sono locali flottanti:
*   vplus  = OUT + Δ (Δ ≈ 4,4 V: stringa 7×1N4148 + Vbe(Q7))
*   vminus = OUT − Δ (speculare PNP)
* Pass serie: Q7 NPN da +24 (sorgente), Q8 PNP da −24 (pozzo);
* bias stringhe: R 4,7 k dal rail statico opposto (corrente 4-9 mA,
* handoff dolce: oltre OUT ≈ ±19,3 il pass satura e il rail resta
* statico ±23,7 → clamp ±22,2 → tetto OUT ≈ ±21,5 atteso).
* Clamp della macro riferito a vp/vm → il tracking è modellato
* automaticamente. PSRR/rumore stringa NON modellati (macro ideale):
* da verificare a banco (PSRR chip ~120 dB LF).
* STATO MODELLI [PROVVISORIO — regola 3]: OPAMAC = macromodello v0.2
* (GBW 80 MHz, A0 120 dB, 2° polo 40 MHz, clamp ±(rail−1,5));
* MJE340/350 rappresentativi; 1N4148 parametri standard LTspice.
* Semplificazioni: niente servo DC, niente protezioni, carico 10 k.
* Nota corrente reale: la macro NON assorbe Iq (VCVS ideale); nel
* reale OPA1612 Iq ≈ 40 mA → i pass/bias vanno dimensionati per
* 40 mA + drive (qui vedono solo il drive, pochi mA).

* ---------- Macromodello OPA1612 (come v0.2) ----------
.subckt OPAMAC inp inn out vp vm
E1 x 0 value={1000*(V(inp)-V(inn))}
R1 x p1 1k
C1 p1 0 1.99u
E2 y 0 p1 0 1000
R2 y p2 1k
C2 p2 0 3.98p
E3 out 0 value={limit(V(p2),V(vm)+1.5,V(vp)-1.5)}
.ends OPAMAC

* ---------- Modelli ----------
.model MJE340 NPN(IS=1e-13 BF=150 VAF=150 IKF=0.5 BR=5 CJC=4p CJE=15p TF=2n TR=20n RB=5 RC=1 RE=0.1 Vceo=300 Icrating=500m mfg=ON)
.model MJE350 PNP(IS=1e-13 BF=100 VAF=120 IKF=0.4 BR=3 CJC=4p CJE=15p TF=5n TR=50n RB=5 RC=1.5 RE=0.15 Vceo=300 Icrating=500m mfg=ON)
.model QMULT NPN(IS=1e-14 BF=200 VAF=100 CJC=8p CJE=25p TF=400p)
.model DIO D(Is=2.52n Rs=0.568 N=1.752 Cjo=4p Tt=4n)

* ---------- Alimentazioni statiche ----------
Vp24 vp24 0 DC 24
Vm24 vm24 0 DC -24

* ---------- Ingresso ----------
V1 in 0 SINE(0 {amp} 1k)

* ---------- Bootstrap rail SUPERIORE ----------
Rbu vp24 bu 4.7k
Q7 vp24 bu vplus MJE340
D1 bu s1 DIO
D2 s1 s2 DIO
D3 s2 s3 DIO
D4 s3 s4 DIO
D5 s4 s5 DIO
D6 s5 s6 DIO
D7 s6 out DIO

* ---------- Bootstrap rail INFERIORE ----------
* Q8 PNP: E = vminus (sink verso −24: la Iq reale del chip alimenta
* il nodo; in sim la macro non assorbe Iq → bleed 10k solo-sim)
Rbl nb2 vm24 4.7k
Q8 vm24 nb2 vminus MJE350
Rbleed vminus vm24 10k
D8 out t1 DIO
D9 t1 t2 DIO
D10 t2 t3 DIO
D11 t3 t4 DIO
D12 t4 t5 DIO
D13 t5 t6 DIO
D14 t6 nb2 DIO

* ---------- Composito v0.2 (rail = bootstrap) ----------
X1 in out drv vplus vminus OPAMAC
Q3 drv mid b2 QMULT
Ra drv mid 2.2k
Rbm mid b2 1k
Q1 vp24 drv e1 MJE340
Q2 vm24 b2 e2 MJE350
Re1 e1 out 33
Re2 e2 out 33

* ---------- Carico ----------
RL out 0 10k

* ---------- Analisi ----------
.options noopiter
.tran 0 12m 0 1u
.step param amp 10 22 2
.meas tran vpk_max MAX V(out) FROM 6m TO 12m
.meas tran vpk_min MIN V(out) FROM 6m TO 12m
.meas tran vp_max MAX V(vplus) FROM 6m TO 12m
.meas tran vp_min MIN V(vplus) FROM 6m TO 12m
.meas tran vm_max MAX V(vminus) FROM 6m TO 12m
.meas tran vm_min MIN V(vminus) FROM 6m TO 12m
.meas tran idrv_max MAX V(drv) FROM 6m TO 12m
.meas tran idrv_min MIN V(drv) FROM 6m TO 12m
.meas tran istr_max MAX I(Rbu) FROM 6m TO 12m
.meas tran istr_min MIN I(Rbl) FROM 6m TO 12m
.end
