* ============================================================
* MASTER OUT v0.3 — Test 10: rumore residuo d'uscita
* .noise su OUT (guadagno ~1: inoise ≈ onoise): densita' e livelli
* a 10/100/1k/10k/35k Hz + massimo in banda. Integrazione 20 Hz-
* 22 kHz calcolata a mano dai punti (spettro atteso termico-piatto
* sopra ~100 Hz): Vrms ≈ densita' × √(BW).
* Riferimento: doc §7 budget rumore; residuo MODULO master-out
* (catena a monte = EQ/VCA con proprio budget). Target indicativo
* del progetto: contributi locali sotto −100 dBu (0,775 µV).
* --- LIMITI DICHIARATI DELLA SIMULAZIONE ---
* 1. La macro OPAMAC e' senza rumore: l'OPA1612 reale aggiunge
*    1,1 nV/√Hz × noise gain 1,001 → ~0,17 µV su 22 kHz (−134 dBu):
*    trascurabile contro la rete passiva, somma in quadratura.
* 2. La macro NON ha PSRR: il rumore delle stringhe bootstrap sui
*    rail non ha percorso verso OUT in sim. Nel chip reale PSRR
*    ~120 dB LF → contributo ancora piu' piccolo. Analisi nel doc.
* 3. Rumore 1/f dei BJT del diamond: incluso dai modelli LTspice.
* Rete: composito + bootstrap CCS (Test 7b) + rete servo DC finale
* (Rsrc 1k, Rinj 1M, Rf 1k, Rg 1M, integratore 220k/15n, OPAMP0
* ideale senza rumore — il TL061 reale via Rinj 1M su nodo a bassa
* Z: contributo ~nullo, da confermare a banco).
* Modelli [PROVVISORIO — regola 3].
* ============================================================

.inc opamac-isup.inc

.subckt OPAMP0 inp inn out
E1 out 0 value={limit(1e5*(V(inp)-V(inn)),-16,16)}
.ends OPAMP0

.model MJE340 NPN(IS=1e-13 BF=150 VAF=150 IKF=0.5 BR=5 CJC=4p CJE=15p TF=2n TR=20n RB=5 RC=1 RE=0.1 Vceo=300 Icrating=500m mfg=ON)
.model MJE350 PNP(IS=1e-13 BF=100 VAF=120 IKF=0.4 BR=3 CJC=4p CJE=15p TF=5n TR=50n RB=5 RC=1.5 RE=0.15 Vceo=300 Icrating=500m mfg=ON)
.model QMULT NPN(IS=1e-14 BF=200 VAF=100 CJC=8p CJE=25p TF=400p)
.model DIO D(Is=2.52n Rs=0.568 N=1.752 Cjo=4p Tt=4n)
.model NJF245 NJF(Beta=4m Vto=-1.4 Lambda=10m Cgs=10p Cgd=4p Is=10f)

Vp24 vp24 0 DC 24
Vm24 vm24 0 DC -24

* Ingresso (sorgente + Rsrc del nodo servo)
V1 src 0 AC 1
Rsrc src in 1k

* Bootstrap superiore (CCS JFET)
J1 vp24 j1s bu NJF245
Rj1 j1s bu 47
Q7 vp24 bu vplus MJE340
D1 bu s1 DIO
D2 s1 s2 DIO
D3 s2 s3 DIO
D4 s3 s4 DIO
D5 s4 s5 DIO
D6 s5 s6 DIO
D7 s6 s7 DIO
D15 s7 s8 DIO
D16 s8 out DIO

* Bootstrap inferiore (CCS JFET)
J2 nb2 j2s vm24 NJF245
Rj2 j2s vm24 47
Q8 vm24 nb2 vminus MJE350
D8 out t1 DIO
D9 t1 t2 DIO
D10 t2 t3 DIO
D11 t3 t4 DIO
D12 t4 t5 DIO
D13 t5 t6 DIO
D14 t6 t7 DIO
D17 t7 t8 DIO
D18 t8 nb2 DIO

* Composito v0.2 (feedback via Rf, nodo inn)
X1 in inn drv vplus vminus OPAMAC
Q3 drv mid b2 QMULT
Ra drv mid 2.2k
Rbm mid b2 1k
Q1 vp24 drv e1 MJE340
Q2 vm24 b2 e2 MJE350
Re1 e1 out 33
Re2 e2 out 33
* NOTA v0.3c (misurato, THD): Cboot 1u+100n rail↔OUT PROVATI E RIMOSSI:
* interagendo col kink degli specchi di assorbimento (cambio ramo a ogni
* attraversamento della corrente di carico) producevano glitch 0,3-0,4 V
* una volta per periodo → THD 5,9-38 % (comb). Il picco closed-loop MHz
* (fuori banda, innocuo: g8hz-35k piatto) si lascia com'era in v0.2
* (+3,3 dB @50 MHz senza carico). A banco: eventuale decoupling rail
* da provare SOLO con valori piccoli (100n) e misura THD prima/dopo.

* Rete servo DC
Rf inn out 1k
Rg inn 0 1Meg
Rinj svout in 1Meg
X2 0 svinn svout OPAMP0
R1s out svinn 220k
C1s svinn svout 15n

* Carico
RL out 0 10k

.options noopiter
.nodeset V(out)=0 V(in)=0 V(inn)=0 V(drv)=0.7 V(vplus)=5.4 V(vminus)=-5.4 V(svout)=0 V(svinn)=0
.noise V(out) V1 dec 200 10 100k
.meas noise n10hz FIND V(onoise) AT 10
.meas noise n100hz FIND V(onoise) AT 100
.meas noise n1khz FIND V(onoise) AT 1k
.meas noise n10khz FIND V(onoise) AT 10k
.meas noise n35khz FIND V(onoise) AT 35k
.meas noise nmax MAX V(onoise)
.end
