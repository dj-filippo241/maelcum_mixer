* MASTER - rumore al pin EC- del VCA del MONO a tasto spento, prima e dopo il todo 288
* Il VCA a 0 dB non porta in uscita il rumore del pin: lo trasforma in modulazione del guadagno
* (0,164 dB per mV). Qui si misura la densita' al pin, per confrontare le due catene.
* v=0: inseguitore + 7,15k / 1k. v=1: x2,36 (10,2k / 7,5k) + 18,2k / 1k.
* Tasto aperto: MONO_SW a massa con 10k, 10k in serie, 100n. VA e' solo la sorgente che .noise chiede.
* Op-amp OPA1612 lineare (en 1,1 nV: Rn 73 ohm), E a 4 nodi.
.subckt OPN inp inn out
Rn inp inx 73
E1 xx 0 inx inn 3.16e6
R1 xx p1 3955
C1 p1 0 1.59u
E2 out 0 p1 0 1
.ends OPN
.param v=0
.param mrf={if(v,10.2k,1m)} mrg={if(v,7.5k,1e12)} mrt={if(v,18.2k,7.15k)}
VA a 0 DC 0 AC 1
Rsw msw a 10k
Rrc msw mrc 10k
Crc mrc 0 100n
Xb mrc mn mbuf OPN
Rmf mn mbuf {mrf}
Rmg mn 0 {mrg}
Rmt mbuf ecs {mrt}
Rmb ecs 0 1k
.step param v list 0 1
.noise V(ecs) VA dec 50 20 20k
.meas noise on1 FIND V(onoise) AT 20
.meas noise on2 FIND V(onoise) AT 31.5
.meas noise on3 FIND V(onoise) AT 50
.meas noise on4 FIND V(onoise) AT 80
.meas noise on5 FIND V(onoise) AT 125
.meas noise on6 FIND V(onoise) AT 200
.meas noise on7 FIND V(onoise) AT 315
.meas noise on8 FIND V(onoise) AT 500
.meas noise on9 FIND V(onoise) AT 800
.meas noise on10 FIND V(onoise) AT 1250
.meas noise on11 FIND V(onoise) AT 2000
.meas noise on12 FIND V(onoise) AT 3150
.meas noise on13 FIND V(onoise) AT 5000
.meas noise on14 FIND V(onoise) AT 8000
.meas noise on15 FIND V(onoise) AT 12500
.meas noise on16 FIND V(onoise) AT 20000
.meas noise g1k FIND gain AT 1000
.end
