* ============================================================
* MASTER OUT — stadio composito: risposta in frequenza e stabilita'
* Test 2: banda 8 Hz-35 kHz ±0,5 dB con carico capacitivo (cavo)
* Riferimento: docs/fase1/master-out.md §1 (voce 44) e §6.2
* ============================================================
* Modelli [PROVVISORIO] — stesse note di comp-swing.cir

.subckt OPAMAC inp inn out vp vm
E1 x 0 value={1000*(V(inp)-V(inn))}
R1 x p1 1k
C1 p1 0 1.99u
E2 y 0 p1 0 1000
R2 y p2 1k
C2 p2 0 3.98p
E3 out 0 value={limit(V(p2),V(vm)+1.5,V(vp)-1.5)}
.ends OPAMAC

.model MJE340 NPN(IS=1e-13 BF=150 VAF=150 IKF=0.5 BR=5 CJC=4p CJE=15p TF=2n TR=20n RB=5 RC=1 RE=0.1 Vceo=300 Icrating=500m mfg=ON)
.model MJE350 PNP(IS=1e-13 BF=100 VAF=120 IKF=0.4 BR=3 CJC=4p CJE=15p TF=5n TR=50n RB=5 RC=1.5 RE=0.15 Vceo=300 Icrating=500m mfg=ON)
.model QMULT NPN(IS=1e-14 BF=200 VAF=100 CJC=8p CJE=25p TF=400p)

Vp24 vp24 0 DC 24
Vm24 vm24 0 DC -24
Vp18 vp18 0 DC 18
Vm18 vm18 0 DC -18

* Sorgente piccola segnale per AC
V1 in 0 DC 0 AC 1

X1 in out drv vp18 vm18 OPAMAC
Q3 drv mid b2 QMULT
Ra drv mid 2.2k
Rb mid b2 1k
Q1 vp24 drv e1 MJE340
Q2 vm24 b2 e2 MJE350
Re1 e1 out 33
Re2 e2 out 33

* Carico: 10 kOhm + capacita' cavo. Doc §6.2: cavo 100 m ~ 10 nF.
* .step su 0/10/33 nF per vedere il margine (33 nF = caso ostile)
RL out 0 10k
Cload out 0 {cl}
.step param cl LIST 0 10n 33n

* ---------- Analisi ----------
.ac dec 200 1 100Meg
* Guadagno a 8 Hz e 35 kHz (requisito ±0,5 dB in banda)
.meas ac g8hz FIND mag(V(out)) AT 8
.meas ac g35khz FIND mag(V(out)) AT 35k
.meas ac g1khz FIND mag(V(out)) AT 1k
* Picco di guadagno in banda audio = proxy di margine di fase:
* se max <= 1,02 (~0,17 dB) il carico non fa suonare la campana
.meas ac gmax MAX mag(V(out))
* Frequenza a -3 dB
.meas ac f3db WHEN mag(V(out))=0.707
.end
