* GENERIC MONO v0.1 — rumore MODULO all'uscita MSUM L.
* jack -> R serie 1k -> C 100n film + bias 1M -> buffer FET OP1654 ->
* pot GAIN 10k passivo (a = frazione) -> make-up +10 dB (OP1654, 2,15k/1k)
* -> EQ2 detent -> driver. .step a: 0,001 (chiuso) / 0,316 (0 dB) / 1 (+10)
* Sorgente: 1k (uscita synth/drum machine tipica).
.include ../lib/opamp-audio.inc
.param a=0.316 rs=1k
Vcc vcc 0 18
Vee vee 0 -18
V1 vin 0 0 AC 1
Rs vin j {rs}
Rpr j jp 1k
Cin jp b 100n
Rbias b 0 1Meg
Xb b bo bo vcc vee OP1654
Rpt bo w {10k*(1-a)+1m}
Rpb w 0 {10k*a+1m}
Xm w mf pre vcc vee OP1654
Rmf pre mf 2.15k
Rmg mf 0 1k
.include backend.inc
.step param a list 0.001 0.316 1
.noise V(outl) V1 dec 20 10 100k
.meas noise on1 FIND V(onoise) AT 20
.meas noise on2 FIND V(onoise) AT 31.5
.meas noise on3 FIND V(onoise) AT 50
.meas noise on4 FIND V(onoise) AT 80
.meas noise on5 FIND V(onoise) AT 125
.meas noise on6 FIND V(onoise) AT 200
.meas noise on7 FIND V(onoise) AT 315
.meas noise on8 FIND V(onoise) AT 500
.meas noise on9 FIND V(onoise) AT 800
.meas noise on10 FIND V(onoise) AT 1250
.meas noise on11 FIND V(onoise) AT 2000
.meas noise on12 FIND V(onoise) AT 3150
.meas noise on13 FIND V(onoise) AT 5000
.meas noise on14 FIND V(onoise) AT 8000
.meas noise on15 FIND V(onoise) AT 12500
.meas noise on16 FIND V(onoise) AT 20000
.meas noise g1k FIND gain AT 1000
.end
