* MASTER LEVEL (dec. 139: scatto al centro = 0 dB) -> CV dei due VCA (todo 181).
* Law [PROVVISORIO, dec. 129]: 0 -> +6 dB lineari in dB sopra il centro, 40 log10(2 theta)
* sotto (-12 dB al 25 %), fondo corsa chiesto a -140 dB (il VCA si ferma al suo floor).
* Valori E96 dal fit (master_fit.py, 4 rami), taratura a 35 C. Pot rovescio: Vx = 5(1 - theta),
* sopra il centro tutti i diodi sono spenti. Ramo d'offset Roff verso -5 V: a fine corsa
* l'uscita e' +0,366 V = +6 dB. Convenzione della famiglia (come il fader): uscita negativa
* = taglio; il verso sul pin EC- lo da' lo stadio del partitore (sistema-vca-trim §3.2).
* Scala 61 mV/dB (x10). .step temp 20/35/50 = telaio fanless.
.include ../lib/opamp-audio.inc
.model D1N4148 D(Is=2.52n Rs=0.568 N=1.752 Cjo=4p Tt=4n)
Vcc vcc 0 15
Vee vee 0 -15
Vref nref 0 -5
Vx x 0 0
Rm x sj 68.1k
Roff nref sj 137k
Ra1 x n1 1.91k
Rb1 n1 nref 2.43k
D1 n1 sj D1N4148
Ra2 x n2 16.9k
Rb2 n2 nref 38.3k
D2 n2 sj D1N4148
Ra3 x n3 1.82k
Rb3 n3 nref 2.43k
D3 n3 sj D1N4148
Ra4 x n4 1.96k
Rb4 n4 nref 2.61k
D4 n4 sj D1N4148
Rf sj out 10k
Xop 0 sj out vcc vee OP1654
.dc Vx 0 5 0.005
.step temp list 20 35 50
.meas dc m0 FIND V(out) AT 0.0000
.meas dc m1 FIND V(out) AT 0.5000
.meas dc m2 FIND V(out) AT 1.0000
.meas dc m3 FIND V(out) AT 1.5000
.meas dc m4 FIND V(out) AT 2.0000
.meas dc m5 FIND V(out) AT 2.2500
.meas dc m6 FIND V(out) AT 2.5000
.meas dc m7 FIND V(out) AT 2.6500
.meas dc m8 FIND V(out) AT 2.7500
.meas dc m9 FIND V(out) AT 3.0000
.meas dc m10 FIND V(out) AT 3.2500
.meas dc m11 FIND V(out) AT 3.5000
.meas dc m12 FIND V(out) AT 3.7500
.meas dc m13 FIND V(out) AT 4.0000
.meas dc m14 FIND V(out) AT 4.2500
.meas dc m15 FIND V(out) AT 4.5000
.meas dc m16 FIND V(out) AT 4.7500
.meas dc m17 FIND V(out) AT 5.0000
.end
