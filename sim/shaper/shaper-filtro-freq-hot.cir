* VARIANTE CALDA (dec. 111, todo 49): 40 C ambiente -> interno 50-75 C. Copia di shaper-filtro-freq.cir con .step temp 50 65 75.
* ============================================================
* SHAPER FREQUENZA FILTRO — law DECISIONE 102 (Xone:96 nel 90 % centrale)
* Uscita lineare in OTTAVE (0,5 V/ottava, verso il converter expo):
*   theta 0-5 %  : 10 -> 20 Hz      (1 ottava in 0,25 V   = 2,000 V/V)
*   theta 5-95 % : 20 Hz -> 20 kHz  (10 ottave in 4,5 V   = 1,111 V/V)
*   theta 95-100 %: 20 -> 35 kHz    (0,807 ott. in 0,25 V = 1,614 V/V)
* Famiglia unica (sistema-shaper.md): sommatore invertente Rf 10k,
* ramo principale Rm, ramo ALTO (diodo diretto, si accende sopra 4,75 V),
* ramo BASSO (diodo rovesciato, si accende sotto 0,25 V; qui Rb va a
* -5 V: e' lei che porta la soglia a Vx positivo). Valori E96.
* Verifica: .dc sulla manopola a 20 / 35 / 50 C. Zero e fondo scala
* tarati a 35 C su 5 % e 95 % (due trimmer). Pre-distorsione del
* converter (filter-module par. 4) NON inclusa.
* ============================================================
.model D4148 D(Is=2.52n Rs=0.568 N=1.752 Cjo=4p M=0.4 tt=20n Eg=1.11 Xti=3)
.param rah=20k rbh=24.3k ral=11.3k rbl=80.6k
Vx vx 0 DC 0
Vm m5 0 DC -5
Rm vx vg 9.09k
Rah vx nh {rah}
Rbh nh m5 {rbh}
Dh nh vg D4148
Ral vx nl {ral}
Rbl nl m5 {rbl}
Dl vg nl D4148
Rf vg out 10k
E1 out 0 0 vg 1e6
.dc Vx 0 5 0.0125
.step temp list 50 65 75
.meas dc v0000 FIND V(out) AT 0.0000
.meas dc v0025 FIND V(out) AT 0.1250
.meas dc v0050 FIND V(out) AT 0.2500
.meas dc v0100 FIND V(out) AT 0.5000
.meas dc v0250 FIND V(out) AT 1.2500
.meas dc v0400 FIND V(out) AT 2.0000
.meas dc v0500 FIND V(out) AT 2.5000
.meas dc v0600 FIND V(out) AT 3.0000
.meas dc v0750 FIND V(out) AT 3.7500
.meas dc v0900 FIND V(out) AT 4.5000
.meas dc v0950 FIND V(out) AT 4.7500
.meas dc v0975 FIND V(out) AT 4.8750
.meas dc v1000 FIND V(out) AT 5.0000
.end
