* REROUTE FX: 0...-100 dB, 61 mV/dB a scala x10 (uscita 0...-6,1 V -> /10 -> EC+)
* SHAPER a tratti — famiglia unica (dec. 70): UN op-amp sommatore invertente
* + rami diodo/resistori. Ogni ramo: Vx -> Ra -> nodo -> diodo -> massa
* virtuale; il nodo e' tirato a -5 V da Rb: il ramo entra in conduzione
* sopra una soglia e AGGIUNGE pendenza (curva convessa). Vout = -Rf*I.
* Valori E96 dal fit (sim/shaper/shaper_fit.py), taratura a 35 C.
* .step temp 20/35/50 = escursione interna del telaio fanless.
.include ../lib/opamp-audio.inc
.model D1N4148 D(Is=2.52n Rs=0.568 N=1.752 Cjo=4p Tt=4n)
Vcc vcc 0 15
Vee vee 0 -15
Vref nref 0 -5
Vx x 0 0
Rm x sj 37.4k
Ra1 x n1 43.2k
Rb1 n1 nref 1Meg
D1 n1 sj D1N4148
Ra2 x n2 18.7k
Rb2 n2 nref 40.2k
D2 n2 sj D1N4148
Ra3 x n3 2.61k
Rb3 n3 nref 3.83k
D3 n3 sj D1N4148
Rf sj out 10k
Xop 0 sj out vcc vee OP1654
.dc Vx 0 5 0.005
.step temp list 20 35 50
.meas dc m0 FIND V(out) AT 0.0000
.meas dc m1 FIND V(out) AT 0.1250
.meas dc m2 FIND V(out) AT 0.2500
.meas dc m3 FIND V(out) AT 0.5000
.meas dc m4 FIND V(out) AT 0.7500
.meas dc m5 FIND V(out) AT 1.1250
.meas dc m6 FIND V(out) AT 1.5000
.meas dc m7 FIND V(out) AT 2.1250
.meas dc m8 FIND V(out) AT 2.7500
.meas dc m9 FIND V(out) AT 3.3750
.meas dc m10 FIND V(out) AT 4.0000
.meas dc m11 FIND V(out) AT 4.5000
.meas dc m12 FIND V(out) AT 5.0000
.end
