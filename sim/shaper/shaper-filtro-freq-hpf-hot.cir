* VARIANTE CALDA (come shaper-filtro-freq-hot.cir): .step temp 50 65 75.
* ============================================================
* SHAPER FREQUENZA FILTRO, SEZIONE HPF — law DECISIONE 137 (2026-10-27)
* Uscita lineare in OTTAVE (0,5 V/ottava, verso il converter expo):
*   theta 0-95 %  : 20 Hz -> 20 kHz (10 ottave in 4,75 V = 1,053 V/V)
*   theta 95-100 %: 20 -> 35 kHz    (0,807 ott. in 0,25 V = 1,614 V/V)
* Come shaper-filtro-freq.cir (sezione LPF, dec. 102) SENZA ramo basso:
* Rm 9,09k -> 9,53k (pendenza 10 ottave su 95 % di corsa), ramo alto
* Rah 20k -> 17,8k (gain aggiunto Rf/Rah 0,56), Rbh 24,3k -> 21,5k
* (stessa soglia morbida, Rbh/Rah ~1,2). Valori E96.
* Verifica: .dc sulla manopola a 20 / 35 / 50 C. Zero e fondo scala
* tarati a 35 C (due trimmer, come la LPF).
* ============================================================
.model D4148 D(Is=2.52n Rs=0.568 N=1.752 Cjo=4p M=0.4 tt=20n Eg=1.11 Xti=3)
.param rah=17.8k rbh=21.5k
Vx vx 0 DC 0
Vm m5 0 DC -5
Rm vx vg 9.53k
Rah vx nh {rah}
Rbh nh m5 {rbh}
Dh nh vg D4148
Rf vg out 10k
E1 out 0 0 vg 1e6
.dc Vx 0 5 0.0125
.step temp list 50 65 75
.meas dc v0000 FIND V(out) AT 0.0000
.meas dc v0025 FIND V(out) AT 0.1250
.meas dc v0050 FIND V(out) AT 0.2500
.meas dc v0100 FIND V(out) AT 0.5000
.meas dc v0250 FIND V(out) AT 1.2500
.meas dc v0400 FIND V(out) AT 2.0000
.meas dc v0500 FIND V(out) AT 2.5000
.meas dc v0600 FIND V(out) AT 3.0000
.meas dc v0750 FIND V(out) AT 3.7500
.meas dc v0900 FIND V(out) AT 4.5000
.meas dc v0085 FIND V(out) AT 0.4250
.meas dc v0950 FIND V(out) AT 4.7500
.meas dc v0975 FIND V(out) AT 4.8750
.meas dc v1000 FIND V(out) AT 5.0000
.end
