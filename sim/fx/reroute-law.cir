* FX v0.2 (§11.1) — LAW A TRATTI DEL REROUTE: verifica end-to-end
* Catena (SPEC §7): pot 0-5 V → buffer CV → shaper non lineare → smoothing
* 1-5 ms → EC− del THAT 218x (6,1 mV/dB). Solo attenuazione (G ≤ 0 dB).
* Law BLOCCATA (SPEC §7): θ 0-20% → −∞…−40 dB; 20-45% → −40…−20;
* 45-70% → −20…−10; 70-85% → −10…−4; 85-95% → −4…−1; 95-100% → −1…0.
* "−∞" = floor del VCA (−100 dB, gain range datasheet <−100).
* Shaper = PWL comportamentale (V_pot → V_ec = −G·6,1 mV); implementazione
* reale = rete diodi/resistori a breakpoint, famiglia dello shaper filtro
* (filter-module §4), trimmer a banco. Smoothing R 10k + C 100n = 1 ms.
* Griglia: 6 breakpoint SPEC + 7 punti medi (13 step).
.include ../lib/that2181.inc
.param th=1.0
Vcc vcc 0 DC 18
Vee vee 0 DC -18
* Segnale: ritorno a 0 dBu nominale (1 kHz)
V1 in 0 DC 0 AC 1
* Pot 0-5 V (ratiometrico)
Vpot vp 0 DC {5*th}
* Shaper PWL: breakpoint (V_pot, V_ec) dalla tabella SPEC
Bshp shp 0 V={if(V(vp)<1, 0.610-0.366*V(vp), if(V(vp)<2.25, 0.244-0.0976*(V(vp)-1), if(V(vp)<3.5, 0.122-0.0488*(V(vp)-2.25), if(V(vp)<4.25, 0.061-0.0488*(V(vp)-3.5), if(V(vp)<4.75, 0.0244-0.0366*(V(vp)-4.25), 0.0061-0.0244*(V(vp)-4.75))))))}
* Smoothing 1 ms (10k + 100n) + buffer CV (ideale)
Rsm shp smr 10k
Csm smr 0 100n
Bbuf ecm 0 V={V(smr)}
* VCA reroute (EC+ a massa: G = −V_ecm/6,1m dB)
Xg in out 0 ecm vcc vee THAT2181
*
.step param th LIST 0 0.10 0.20 0.325 0.45 0.575 0.70 0.775 0.85 0.90 0.95 0.975 1.0
.ac dec 100 100 10k
.meas ac g1k FIND mag(V(out)) AT 1k
.meas ac g100 FIND mag(V(out)) AT 100
.meas ac g10k FIND mag(V(out)) AT 10k
.end
