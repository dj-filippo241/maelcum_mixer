* MODULO FX v0.3 — SELF-FEEDBACK DRY LOOP (dec. 91): pedale ASSENTE,
* cavo patch send->return diretto. Il bounding NON viene piu' dal tanh
* del pedale: restano solo i clamp degli stadi (±16,5 V su dominio ±18).
* Questo e' il caso K4 (dec. 84: disciplina operatore): con GAIN VCA del
* ritorno alto e self al massimo l'anello secco oscilla e sbatte sui
* clamp interni — documentato, recuperabile chiudendo il pot.
* Casi: gdry 1,0 (unity secco: sostiene dalla .ic — in realta' il rumore
* d'ingresso cresce fino ai clamp anche sotto unity di pochi dB),
* 3,0 e 10,0 (GAIN ritorno ~+10/+20 dB con self 0 dB: runaway → clamp).
.param gdry=3
.step param gdry LIST 1.0 3.0 10.0
B1 n1 0 V={gdry*V(ret)}
R1 n1 n2 10k
C1 n2 0 400p
Ecl n2c 0 value={limit(V(n2),-16.5,16.5)}
R2 n2c ret 10k
C2 ret 0 400p
.ic V(ret)=0.01
.tran 0 50m 0 10u
.meas tran ret_pk MAX V(ret) FROM 30m TO 50m
.meas tran ret_min MIN V(ret) FROM 30m TO 50m
.end
