* =====================================================================
* FILTRO — D5 passo 2d (2026-10-14): limitatore come PERDITA NON LINEARE
* buffer BP (bassa impedenza) -> Rl -> 2+2 1N4148 antiparallele -> summer.
* Sotto ~1,1 V non conduce; sopra smorza l'anello con corrente presa dal
* buffer, non dall'OTA: l'ampiezza non dipende da Iabc. Core (a'). = OTA con PARTITORE davanti
* agli ingressi degli OTA (pratica dei filtri OTA reali, Sherman compreso).
* Partitore k = Rd/(Ra+Rd), Rd 100 ohm: il tetto di stato a fc diventa
* 52 mV/k; il rumore dell'OTA riferito agli stati sale di 1/k.
* C = 33 nF * k: la mappa Iabc -> fc resta quella della v0.2 (converter e
* shaper invariati). RES: stessi OTA del passo 1, ingresso dallo stesso
* partitore dello stato BP, Iabc_res = 7,365 uA * |gres| / k.
* Griglia come d5-core.cir: gres (law dec. 102) x livello x frequenza x k.
* Avvio con uic (il .op non converge con gli OTA RES a Iabc ~0).
* Livelli (PICCO): -30 dBu 0,0346 | -10 dBu 0,346 | 0 dBu 1,096
* =====================================================================
.include ../lib/lm13700.inc
.include ../lib/opamp-audio.inc
Vcc vcc 0 DC 15
Vee vee 0 DC -15
.param A=0 gres=1 k=0.05 Iab=10.8u Rl=1k
.param Ra={100*(1/k-1)} Ci={33n*k}
.param Ip={7.365u/k*max(gres,0)+1n} In={7.365u/k*max(-gres,0)+1n}
V1 vin 0 SINE(0 {A} {f})
Ix1 vcc iabc1 DC {Iab}
Ix2 vcc iabc2 DC {Iab}
Ixp vcc iabp DC {Ip}
Ixn vcc iabn DC {In}
* --- summer ---
Rvin vin ns 10k
Rlp lp_b ns 10k
Rf ns hp 10k
Xsum 0 ns hp vcc vee OP1654
* --- integratori OTA reali + buffer di stato ---
Ra1 hp hpk {Ra}
Rd1 hpk 0 100
Xota1 hpk 0 bp iabc1 d1 d2 vcc vee LM13700
C1i bp 0 {Ci}
Rb1 bp 0 100Meg
Xb1 bp bp_b bp_b vcc vee OP1654
Ra2 bp_b bpk {Ra}
Rd2 bpk 0 100
Xota2 bpk 0 lp iabc2 d3 d4 vcc vee LM13700
C2i lp 0 {Ci}
Rb2 lp 0 100Meg
Xb2 lp lp_b lp_b vcc vee OP1654
* --- RES: OTA reali nel summer (positivo smorza, negativo innesca) ---
XresP bpk 0 ns iabp d5 d6 vcc vee LM13700
XresN 0 bpk ns iabn d7 d8 vcc vee LM13700
.model D1N4148 D(Is=2.53n Rs=0.568 N=1.752 Cjo=4p M=0.4 Tt=20n)
Rnl bp_b nl {Rl}
Dn1 nl nl1 D1N4148
Dn2 nl1 ns D1N4148
Dn3 ns nl2 D1N4148
Dn4 nl2 nl D1N4148
.ic V(lp)=0.01
.tran 0 1 0 2u uic
.meas tran t1 WHEN V(lp_b)=0 RISE=40
.meas tran t2 WHEN V(lp_b)=0 RISE=60
.meas tran fosc PARAM 20/(t2-t1)
.step param gres LIST -0.1 -0.75
.step param Iab LIST 1.08u 10.8u 108u
.step param Rl LIST 1k 4.7k
.param f=1000
.meas tran lppp PP V(lp_b) FROM 0.9 TO 1
.meas tran lpdc AVG V(lp_b) FROM 0.9 TO 1
.meas tran lprms RMS V(lp_b) FROM 0.9 TO 1
.meas tran bppp PP V(bp_b) FROM 0.9 TO 1
.meas tran hppp PP V(hp) FROM 0.9 TO 1
.end
