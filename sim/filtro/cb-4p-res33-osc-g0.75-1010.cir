* =====================================================================
* FILTRO — core PULITO (c-B) a 4 poli con RES, LIMITATORE 3+3: AUTO-OSCILLAZIONE gres -0.75, fc 1010 Hz
* Circuito di cb-4p-noise-c.cir (f1 12 kHz, Butterworth 0,541 + 1,307) +
* RES con OTA a partitore + limitatore a diodi del D5. VCA ideali (THD e
* rumore assenti nel modello).
* =====================================================================
.include ../lib/that2181.inc
.include ../lib/lm13700.inc
.include ../lib/opamp-audio.inc
Vcc vcc 0 DC 18
Vee vee 0 DC -18
.param f1=12k fc=1010 k=0.0333333
.param Cint={1/(2*pi*f1*10k)} Vc={0.122*log10(fc/f1)} gg={fc/f1}
.param kn={1e-4*if(gg<=1, sqrt(0.063+0.937*gg*gg), pwr(gg,2/3))}
Vctl ecp 0 DC {Vc}
V1 vin 0 SINE(0 {A} {fc})
* --- sezione 1: Q 0.541196 con resistenza dal ramo -bp_b (invertitore reale) ---
Rvin1 vin ns1 10k
Rlp1 lp1_b ns1 10k
Rq1 nbp1 ns1 {0.541196*10k}
Rf1 ns1 hp1 10k
Xsum1 0 ns1 hp1 vcc vee OP1654
Rii1 bp1_b ninv1 10k
Rio1 ninv1 nbp1 10k
Xinv1 0 ninv1 nbp1 vcc vee OP1654
Xg1a hp1 hpg1 ecp 0 vcc vee THAT2181
Rint1a hpg1 nint1a 10k
Cint1a nint1a bp1 {Cint}
Xint1a 0 nint1a bp1 vcc vee OP1654
Rb1a bp1 0 1G
Xb1a bp1 bp1_b bp1_b vcc vee OP1654
Xg1b bp1_b bpg1 ecp 0 vcc vee THAT2181
Rint1b bpg1 nint1b 10k
Cint1b nint1b lp1 {Cint}
Xint1b 0 nint1b lp1 vcc vee OP1654
Rb1b lp1 0 1G
Xb1b lp1 lp1_b lp1_b vcc vee OP1654
* rumore dei due VCA: -98 dBV su I/V 10k = 89 nV/rtHz -> 8,9 pA/rtHz nel nodo
Rn1a vn1a 0 120k
Gn1a 0 nint1a vn1a 0 {kn}
Rn1b vn1b 0 120k
Gn1b 0 nint1b vn1b 0 {kn}
* --- sezione 2: Q 1.306563 con resistenza dal ramo -bp_b (invertitore reale) ---
Rvin2 lp1_b ns2 10k
Rlp2 lp2_b ns2 10k
Rq2 nbp2 ns2 {1.306563*10k}
Rf2 ns2 hp2 10k
Xsum2 0 ns2 hp2 vcc vee OP1654
Rii2 bp2_b ninv2 10k
Rio2 ninv2 nbp2 10k
Xinv2 0 ninv2 nbp2 vcc vee OP1654
Xg2a hp2 hpg2 ecp 0 vcc vee THAT2181
Rint2a hpg2 nint2a 10k
Cint2a nint2a bp2 {Cint}
Xint2a 0 nint2a bp2 vcc vee OP1654
Rb2a bp2 0 1G
Xb2a bp2 bp2_b bp2_b vcc vee OP1654
Xg2b bp2_b bpg2 ecp 0 vcc vee THAT2181
Rint2b bpg2 nint2b 10k
Cint2b nint2b lp2 {Cint}
Xint2b 0 nint2b lp2 vcc vee OP1654
Rb2b lp2 0 1G
Xb2b lp2 lp2_b lp2_b vcc vee OP1654
* rumore dei due VCA: -98 dBV su I/V 10k = 89 nV/rtHz -> 8,9 pA/rtHz nel nodo
Rn2a vn2a 0 120k
Gn2a 0 nint2a vn2a 0 {kn}
Rn2b vn2b 0 120k
Gn2b 0 nint2b vn2b 0 {kn}
* --- RES della sezione 2 (2026-10-21) ---
* Q base 1,307 = Rq2 (resistenza, silenziosa). La RES TOGLIE smorzamento
* con un OTA LM13700 dal ramo +bp2_b attraverso il partitore k 1/30 (come il
* core (a')): anti = 0,765*(1-gres) per gres > 0, 0,765 + 1,414*|gres| oltre
* il 90 % (law dec. 102). Iabc = 5,208 uA/k per unita' di anti (stessa
* taratura dell'OTA RES di d5a: 7,365 uA/k = 1/Q 1,414). A RES minima
* Iabc ~0: niente rumore dall'OTA.
.param anti={if(gres>0, 0.765367*(1-gres), 0.765367+1.414214*(-gres))}
.param Ir={5.208u/k*anti+1n}
Vcco vcco 0 DC 15
Veeo veeo 0 DC -15
Rra bp2_b bpkr {100*(1/k-1)}
Rrd bpkr 0 100
Ixr vcco iabr DC {Ir}
Xres bpkr 0 ns2 iabr r1 r2 vcco veeo LM13700
* limitatore = perdita non lineare dal ramo -bp2_b (polarita' dello
* smorzamento nel (c-B)) al summer: 4,7k + 2+2 1N4148, come il D5
.model D1N4148 D(Is=2.53n Rs=0.568 N=1.752 Cjo=4p M=0.4 Tt=20n)
Rnl nbp2 nl 4.7k
* variante 3+3 diodi (soglia ~1,65 V invece di ~1,1 V)
Dn1 nl nl1 D1N4148
Dn1b nl1 nl1b D1N4148
Dn2 nl1b ns2 D1N4148
Dn3 ns2 nl2 D1N4148
Dn3b nl2 nl2b D1N4148
Dn4 nl2b nl D1N4148
.param A=0 T=0.3
.param gres=-0.75
.ic V(lp2)=0.01
.tran 0 {T} 0 {T/5e4} uic
.meas tran t1 WHEN V(lp2_b)=0 RISE=40
.meas tran t2 WHEN V(lp2_b)=0 RISE=60
.meas tran fosc PARAM 20/(t2-t1)
.meas tran iva MAX (abs(V(hp2))+abs(V(hpg2)))/10k FROM {T*0.7} TO {T}
.meas tran ivb MAX (abs(V(bp2_b))+abs(V(bpg2)))/10k FROM {T*0.7} TO {T}
.meas tran ivc MAX (abs(V(hp1))+abs(V(hpg1)))/10k FROM {T*0.7} TO {T}
.meas tran lprms RMS V(lp2_b) FROM {T*0.7} TO {T}
.meas tran lppp PP V(lp2_b) FROM {T*0.7} TO {T}
.meas tran bppp PP V(bp2_b) FROM {T*0.7} TO {T}
.end
