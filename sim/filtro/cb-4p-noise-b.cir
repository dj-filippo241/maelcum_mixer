* =====================================================================
* FILTRO — core PULITO (c-B) a 4 poli: RUMORE, VARIANTE B (todo 116, 2026-10-21)
* Come cb-4p-noise.cir, con due correzioni dal datasheet THAT 2181:
* - floor -104 dBV a 0 dB con I/V 10k (il -98 e' con 20k): 44,6 nV/rtHz;
* - sopra 0 dB il rumore d'uscita sale di 10 dB ogni 15 dB di guadagno
*   (-98 -> -88 dBV a +15 dB): fattore max(1, g^(2/3)); sotto 0 dB piatto
*   (prudente: la curva di attenuazione, Figure 4, non e' letta).
* Posizione del guadagno: f1 = frequenza a cui g = 1 (Cint = 1/(2pi f1 10k)).
* Per confrontare B1 alla pari col core (a') di d5b-4p-noise-*.cir.
* Cella (c-B) di sim/five-way/cell-vca-ac.cir (validata: law esatta, Q
* invariante): integratori op-amp scalati da due THAT 218x per sezione.
* Due sezioni Butterworth: Q 0,541 + Q 1,307 (RES al minimo), damping con
* resistenza dal ramo -bp_b (invertitore op-amp reale, non sorgente B).
* Scelta di ingegneria: g = 1 a fc max (Cint = 1/(2pi 37 kHz 10k)): i VCA
* lavorano solo in attenuazione (0 ... -71 dB), mai in guadagno.
* Rumore VCA: il modello THAT2181 non ne ha. Floor datasheet -98 dBV
* (unity, 20 kHz) su I/V 10k = 89 nV/rtHz, iniettato come corrente nel
* nodo dell'integratore e tenuto COSTANTE a ogni guadagno (prudente: in
* attenuazione il floor reale scende). resn = 1 aggiunge un terzo VCA (RES)
* che inietta il suo floor nel summer della sezione 2.
* Overdrive v0.2b a valle (od2-noise-b.cir), m = 0 / 0,177 / 0,572 / 1.
* Metodo docs/06: densita' a 16 punti + noise_total.py.
* =====================================================================
.include ../lib/that2181.inc
.include ../lib/opamp-audio.inc
Vcc vcc 0 DC 18
Vee vee 0 DC -18
.param f1=37k fc=37k m=0 resn=0
.param Cint={1/(2*pi*f1*10k)} Vc={0.122*log10(fc/f1)} gg={fc/f1}
.param kn={1e-4*max(1,pwr(gg,2/3))}
Vctl ecp 0 DC {Vc}
V1 vin 0 DC 0 AC 1
* --- sezione 1: Q 0.541196 con resistenza dal ramo -bp_b (invertitore reale) ---
Rvin1 vin ns1 10k
Rlp1 lp1_b ns1 10k
Rq1 nbp1 ns1 {0.541196*10k}
Rf1 ns1 hp1 10k
Xsum1 0 ns1 hp1 vcc vee OP1654
Rii1 bp1_b ninv1 10k
Rio1 ninv1 nbp1 10k
Xinv1 0 ninv1 nbp1 vcc vee OP1654
Xg1a hp1 hpg1 ecp 0 vcc vee THAT2181
Rint1a hpg1 nint1a 10k
Cint1a nint1a bp1 {Cint}
Xint1a 0 nint1a bp1 vcc vee OP1654
Rb1a bp1 0 1G
Xb1a bp1 bp1_b bp1_b vcc vee OP1654
Xg1b bp1_b bpg1 ecp 0 vcc vee THAT2181
Rint1b bpg1 nint1b 10k
Cint1b nint1b lp1 {Cint}
Xint1b 0 nint1b lp1 vcc vee OP1654
Rb1b lp1 0 1G
Xb1b lp1 lp1_b lp1_b vcc vee OP1654
* rumore dei due VCA: -98 dBV su I/V 10k = 89 nV/rtHz -> 8,9 pA/rtHz nel nodo
Rn1a vn1a 0 120k
Gn1a 0 nint1a vn1a 0 {kn}
Rn1b vn1b 0 120k
Gn1b 0 nint1b vn1b 0 {kn}
* --- sezione 2: Q 1.306563 con resistenza dal ramo -bp_b (invertitore reale) ---
Rvin2 lp1_b ns2 10k
Rlp2 lp2_b ns2 10k
Rq2 nbp2 ns2 {1.306563*10k}
Rf2 ns2 hp2 10k
Xsum2 0 ns2 hp2 vcc vee OP1654
Rii2 bp2_b ninv2 10k
Rio2 ninv2 nbp2 10k
Xinv2 0 ninv2 nbp2 vcc vee OP1654
Xg2a hp2 hpg2 ecp 0 vcc vee THAT2181
Rint2a hpg2 nint2a 10k
Cint2a nint2a bp2 {Cint}
Xint2a 0 nint2a bp2 vcc vee OP1654
Rb2a bp2 0 1G
Xb2a bp2 bp2_b bp2_b vcc vee OP1654
Xg2b bp2_b bpg2 ecp 0 vcc vee THAT2181
Rint2b bpg2 nint2b 10k
Cint2b nint2b lp2 {Cint}
Xint2b 0 nint2b lp2 vcc vee OP1654
Rb2b lp2 0 1G
Xb2b lp2 lp2_b lp2_b vcc vee OP1654
* rumore dei due VCA: -98 dBV su I/V 10k = 89 nV/rtHz -> 8,9 pA/rtHz nel nodo
Rn2a vn2a 0 120k
Gn2a 0 nint2a vn2a 0 {kn}
Rn2b vn2b 0 120k
Gn2b 0 nint2b vn2b 0 {kn}
* VCA della RES (solo il suo rumore, resn = 1)
Rnr vnr 0 120k
Gnr 0 ns2 vnr 0 {resn*1e-4}
* --- overdrive v0.2b sull'uscita LP ---
.model D4148 D(Is=2.52n Rs=0.568 N=1.752 Cjo=4p M=0.4 tt=20n)
.param kod=1.171
Ri lp2_b gn 10k
Rfo gn a 20k
X1 0 gn a vcc vee OP1654
R1 a w 2.2k
D1 w p1 D4148
D2 p1 0 D4148
D3 0 q1 D4148
D4 q1 w D4148
Xb w wb wb vcc vee OP1654
Rvx lp2_b vino 10k
Rvw wb vino {10k/kod}
Vs vino 0 DC 0
Fv 0 sn Vs {m}
Rvn vn 0 120k
Gvn 0 sn vn 0 {kn}
Rsa a sn 20k
Rsf sn y 10k
Xs 0 sn y vcc vee OP1654
.nodeset V(bp1)=0 V(lp1)=0 V(hp1)=0 V(bp2)=0 V(lp2)=0 V(hp2)=0
.step param f1 list 37k 1k
.step param fc list 37k 1k
.noise V(y) V1 dec 20 20 20k
.meas noise on1 FIND V(onoise) AT 20
.meas noise on2 FIND V(onoise) AT 31.5
.meas noise on3 FIND V(onoise) AT 50
.meas noise on4 FIND V(onoise) AT 80
.meas noise on5 FIND V(onoise) AT 125
.meas noise on6 FIND V(onoise) AT 200
.meas noise on7 FIND V(onoise) AT 315
.meas noise on8 FIND V(onoise) AT 500
.meas noise on9 FIND V(onoise) AT 800
.meas noise on10 FIND V(onoise) AT 1250
.meas noise on11 FIND V(onoise) AT 2000
.meas noise on12 FIND V(onoise) AT 3150
.meas noise on13 FIND V(onoise) AT 5000
.meas noise on14 FIND V(onoise) AT 8000
.meas noise on15 FIND V(onoise) AT 12500
.meas noise on16 FIND V(onoise) AT 20000
.meas noise g1k FIND gain AT 1000
.meas noise g100 FIND gain AT 100
.end
