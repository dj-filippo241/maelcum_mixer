* =====================================================================
* FILTRO — D5 a 4 poli (todo 46, 2026-10-21): CORE (a') k 1/30 in due
* sezioni (Butterworth: Q 0,541 fissa + Q 1,307 con RES) + OVERDRIVE v0.2.
* Sezioni come d5-chain.cir; la RES e il limitatore stanno sulla sezione 2
* (come nel prototipo MC-FILTRO, sez_a0 + sez_a1). Overdrive come
* d5-chain.cir sull'uscita LP. Tono sul taglio (fc ~1 kHz, Iabc 10,8 uA).
* Ideale a fc: Q1*Q2 = -3,0 / +4,0 / +10,1 / +22,1 dB (RES 0/50/70/85 %).
* Livelli (PICCO): -30 dBu 0,0346 | -10 dBu 0,346 | 0 dBu 1,096
* =====================================================================
.include ../lib/lm13700.inc
.include ../lib/opamp-audio.inc
Vcc vcc 0 DC 15
Vee vee 0 DC -15
.param A=0.346 gres=1 k=0.0333333
.param Ra={100*(1/k-1)} Ci={33n*k}
* d = 1/Q; Iabc_res = 7,365 uA/k * d/sqrt(2) (7,365 uA/k = Q 0,707 nel D5)
.param Iq1={7.365u/k*1.847759/1.414214}
.param Ip={7.365u/k*max(gres,0)*0.765367/1.414214+1n} In={7.365u/k*max(-gres,0)+1n}
V1 vin 0 SINE(0 {A} {f})
* --- sezione 1: Q fissa 0,541 (d = 1,848), RES fissa, niente limitatore ---
Rvin vin ns1 10k
Rlp1 lp1_b ns1 10k
Rf1 ns1 hp1 10k
Xsum1 0 ns1 hp1 vcc vee OP1654
Ra11 hp1 hpk1 {Ra}
Rd11 hpk1 0 100
Xota11 hpk1 0 bp1 iabc1 a1 a2 vcc vee LM13700
C11 bp1 0 {Ci}
Rb11 bp1 0 100Meg
Xb11 bp1 bp1_b bp1_b vcc vee OP1654
Ra12 bp1_b bpk1 {Ra}
Rd12 bpk1 0 100
Xota12 bpk1 0 lp1 iabc2 a3 a4 vcc vee LM13700
C12 lp1 0 {Ci}
Rb12 lp1 0 100Meg
Xb12 lp1 lp1_b lp1_b vcc vee OP1654
Xres1 bpk1 0 ns1 iabq1 a5 a6 vcc vee LM13700
* --- sezione 2: Q 1,307 a RES minima, RES (law dec. 102), limitatore D5 ---
Rin2 lp1_b ns 10k
Rlp lp_b ns 10k
Rf ns hp 10k
Xsum 0 ns hp vcc vee OP1654
Ra1 hp hpk {Ra}
Rd1 hpk 0 100
Xota1 hpk 0 bp iabc3 d1 d2 vcc vee LM13700
C1i bp 0 {Ci}
Rb1 bp 0 100Meg
Xb1 bp bp_b bp_b vcc vee OP1654
Ra2 bp_b bpk {Ra}
Rd2 bpk 0 100
Xota2 bpk 0 lp iabc4 d3 d4 vcc vee LM13700
C2i lp 0 {Ci}
Rb2 lp 0 100Meg
Xb2 lp lp_b lp_b vcc vee OP1654
XresP bpk 0 ns iabp d5 d6 vcc vee LM13700
XresN 0 bpk ns iabn d7 d8 vcc vee LM13700
Ix1 vcc iabc1 DC {10.8u}
Ix2 vcc iabc2 DC {10.8u}
Ix3 vcc iabc3 DC {10.8u}
Ix4 vcc iabc4 DC {10.8u}
Ixq vcc iabq1 DC {Iq1}
Ixp vcc iabp DC {Ip}
Ixn vcc iabn DC {In}
.model D1N4148 D(Is=2.53n Rs=0.568 N=1.752 Cjo=4p M=0.4 Tt=20n)
Rnl bp_b nl 4.7k
Dn1 nl nl1 D1N4148
Dn2 nl1 ns D1N4148
Dn3 ns nl2 D1N4148
Dn4 nl2 nl D1N4148
.model D4148 D(Is=2.52n Rs=0.568 N=1.752 Cjo=4p M=0.4 tt=20n)
E1od a_od 0 value={limit(2*V(lp_b),-16,16)}
R1od a_od w_od 2.2k
Dod1 w_od p1od D4148
Dod2 p1od 0 D4148
Dod3 0 n1od D4148
Dod4 n1od w_od D4148
Rlod w_od 0 1Meg
Bdod d_od 0 V=1.171*V(w_od)-V(lp_b)
Bt50 t50 0 V=V(lp_b)+0.177*V(d_od)
Bt80 t80 0 V=V(lp_b)+0.572*V(d_od)
Bt99 t99 0 V=V(lp_b)+1.000*V(d_od)
.ic V(lp)=0.01
.tran 0 80m 0 5u uic
.step param gres LIST 1 0.444 0.222 0.0556
.step param A LIST 0.0346 0.346 1.096
.param f=1000
.meas tran s1 RMS V(lp1_b) FROM 60m TO 80m
.meas tran r00 RMS V(lp_b) FROM 60m TO 80m
.meas tran r50 RMS V(t50) FROM 60m TO 80m
.meas tran r80 RMS V(t80) FROM 60m TO 80m
.meas tran r99 RMS V(t99) FROM 60m TO 80m
.meas tran pk1 PP V(bp1_b) FROM 60m TO 80m
.four {f} V(lp_b) V(t50) V(t80) V(t99) V(lp1_b)
.end
